** sch_path: design/latches/dlatch.sch

* D latch: transparent while EN=1 (ENB=0); a weak feedback gate holds N1 when closed

.subckt dlatch D EN ENB Q VDD VSS
*.ipin D
*.ipin EN
*.ipin ENB
*.opin Q
*.iopin VDD
*.iopin VSS
XMNI N1 EN D VSS sg13_lv_nmos w=1.0u l=0.13u ng=1 m=1
XMPI N1 ENB D VDD sg13_lv_pmos w=1.0u l=0.13u ng=1 m=1
XMP1 QB N1 VDD VDD sg13_lv_pmos w=1.0u l=0.13u ng=1 m=1
XMN1 QB N1 VSS VSS sg13_lv_nmos w=0.5u l=0.13u ng=1 m=1
XMP2 Q QB VDD VDD sg13_lv_pmos w=1.0u l=0.13u ng=1 m=1
XMN2 Q QB VSS VSS sg13_lv_nmos w=0.5u l=0.13u ng=1 m=1
XMNF N1 ENB Q VSS sg13_lv_nmos w=0.3u l=0.13u ng=1 m=1
XMPF N1 EN Q VDD sg13_lv_pmos w=0.3u l=0.13u ng=1 m=1
.ends
