** sch_path: design/gates/inv_x4.sch

* inverter, 4x drive: N 2.0 um / P 4.0 um

.subckt inv_x4 A Y VDD VSS
*.ipin A
*.opin Y
*.iopin VDD
*.iopin VSS
XMP Y A VDD VDD sg13_lv_pmos w=4.0u l=0.13u ng=1 m=1
XMN Y A VSS VSS sg13_lv_nmos w=2.0u l=0.13u ng=1 m=1
.ends
