** sch_path: design/gates/nand4.sch

* 4-input NAND, N 2.0 um stack / P 1.0 um

.subckt nand4 A B C D Y VDD VSS
*.ipin A
*.ipin B
*.ipin C
*.ipin D
*.opin Y
*.iopin VDD
*.iopin VSS
XMP0 Y A VDD VDD sg13_lv_pmos w=1.0u l=0.13u ng=1 m=1
XMP1 Y B VDD VDD sg13_lv_pmos w=1.0u l=0.13u ng=1 m=1
XMP2 Y C VDD VDD sg13_lv_pmos w=1.0u l=0.13u ng=1 m=1
XMP3 Y D VDD VDD sg13_lv_pmos w=1.0u l=0.13u ng=1 m=1
XMN0 Y A N1 VSS sg13_lv_nmos w=2.0u l=0.13u ng=1 m=1
XMN1 N1 B N2 VSS sg13_lv_nmos w=2.0u l=0.13u ng=1 m=1
XMN2 N2 C N3 VSS sg13_lv_nmos w=2.0u l=0.13u ng=1 m=1
XMN3 N3 D VSS VSS sg13_lv_nmos w=2.0u l=0.13u ng=1 m=1
.ends
