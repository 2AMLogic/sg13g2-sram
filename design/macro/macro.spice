** sch_path: design/macro/macro.sch

* 256 x 32 SRAM macro (128 rows x 64 columns, mux 2): A[0] selects the column, A[7:1] the row; one supply rail VDD/VSS

.subckt macro A[7] A[6] A[5] A[4] A[3] A[2] A[1] A[0] CEN CLK D[31] D[30] D[29] D[28] D[27] D[26] D[25] D[24] D[23] D[22] D[21]
+ D[20] D[19] D[18] D[17] D[16] D[15] D[14] D[13] D[12] D[11] D[10] D[9] D[8] D[7] D[6] D[5] D[4] D[3] D[2] D[1] D[0] Q[31] Q[30] Q[29]
+ Q[28] Q[27] Q[26] Q[25] Q[24] Q[23] Q[22] Q[21] Q[20] Q[19] Q[18] Q[17] Q[16] Q[15] Q[14] Q[13] Q[12] Q[11] Q[10] Q[9] Q[8] Q[7] Q[6]
+ Q[5] Q[4] Q[3] Q[2] Q[1] Q[0] GWEN WEN VDD VSS
*.ipin A[7]
*.ipin A[6]
*.ipin A[5]
*.ipin A[4]
*.ipin A[3]
*.ipin A[2]
*.ipin A[1]
*.ipin A[0]
*.ipin CEN
*.ipin CLK
*.ipin D[31]
*.ipin D[30]
*.ipin D[29]
*.ipin D[28]
*.ipin D[27]
*.ipin D[26]
*.ipin D[25]
*.ipin D[24]
*.ipin D[23]
*.ipin D[22]
*.ipin D[21]
*.ipin D[20]
*.ipin D[19]
*.ipin D[18]
*.ipin D[17]
*.ipin D[16]
*.ipin D[15]
*.ipin D[14]
*.ipin D[13]
*.ipin D[12]
*.ipin D[11]
*.ipin D[10]
*.ipin D[9]
*.ipin D[8]
*.ipin D[7]
*.ipin D[6]
*.ipin D[5]
*.ipin D[4]
*.ipin D[3]
*.ipin D[2]
*.ipin D[1]
*.ipin D[0]
*.opin Q[31]
*.opin Q[30]
*.opin Q[29]
*.opin Q[28]
*.opin Q[27]
*.opin Q[26]
*.opin Q[25]
*.opin Q[24]
*.opin Q[23]
*.opin Q[22]
*.opin Q[21]
*.opin Q[20]
*.opin Q[19]
*.opin Q[18]
*.opin Q[17]
*.opin Q[16]
*.opin Q[15]
*.opin Q[14]
*.opin Q[13]
*.opin Q[12]
*.opin Q[11]
*.opin Q[10]
*.opin Q[9]
*.opin Q[8]
*.opin Q[7]
*.opin Q[6]
*.opin Q[5]
*.opin Q[4]
*.opin Q[3]
*.opin Q[2]
*.opin Q[1]
*.opin Q[0]
*.ipin GWEN
*.ipin WEN
*.iopin VDD
*.iopin VSS
XAL CLK A[7] A[6] A[5] A[4] A[3] A[2] A[1] A[0] CEN GWEN WEN AL[7] AL[6] AL[5] AL[4] AL[3] AL[2] AL[1] AL[0] CENL GWENL WENL VDD
+ VSS addr_latch
XCTL CLK CENL GWENL WENL AL[0] PRE_B WLEN SAE WE SEL0 SEL0B SEL1 SEL1B VDD VSS control
XDEC AL[7] AL[6] AL[5] AL[4] AL[3] AL[2] AL[1] WLEN WL[127] WL[126] WL[125] WL[124] WL[123] WL[122] WL[121] WL[120] WL[119]
+ WL[118] WL[117] WL[116] WL[115] WL[114] WL[113] WL[112] WL[111] WL[110] WL[109] WL[108] WL[107] WL[106] WL[105] WL[104] WL[103] WL[102]
+ WL[101] WL[100] WL[99] WL[98] WL[97] WL[96] WL[95] WL[94] WL[93] WL[92] WL[91] WL[90] WL[89] WL[88] WL[87] WL[86] WL[85] WL[84] WL[83]
+ WL[82] WL[81] WL[80] WL[79] WL[78] WL[77] WL[76] WL[75] WL[74] WL[73] WL[72] WL[71] WL[70] WL[69] WL[68] WL[67] WL[66] WL[65] WL[64]
+ WL[63] WL[62] WL[61] WL[60] WL[59] WL[58] WL[57] WL[56] WL[55] WL[54] WL[53] WL[52] WL[51] WL[50] WL[49] WL[48] WL[47] WL[46] WL[45]
+ WL[44] WL[43] WL[42] WL[41] WL[40] WL[39] WL[38] WL[37] WL[36] WL[35] WL[34] WL[33] WL[32] WL[31] WL[30] WL[29] WL[28] WL[27] WL[26]
+ WL[25] WL[24] WL[23] WL[22] WL[21] WL[20] WL[19] WL[18] WL[17] WL[16] WL[15] WL[14] WL[13] WL[12] WL[11] WL[10] WL[9] WL[8] WL[7] WL[6]
+ WL[5] WL[4] WL[3] WL[2] WL[1] WL[0] VDD VSS row_decoder
XDL CLK D[31] D[30] D[29] D[28] D[27] D[26] D[25] D[24] D[23] D[22] D[21] D[20] D[19] D[18] D[17] D[16] D[15] D[14] D[13] D[12]
+ D[11] D[10] D[9] D[8] D[7] D[6] D[5] D[4] D[3] D[2] D[1] D[0] DL[31] DL[30] DL[29] DL[28] DL[27] DL[26] DL[25] DL[24] DL[23] DL[22]
+ DL[21] DL[20] DL[19] DL[18] DL[17] DL[16] DL[15] DL[14] DL[13] DL[12] DL[11] DL[10] DL[9] DL[8] DL[7] DL[6] DL[5] DL[4] DL[3] DL[2]
+ DL[1] DL[0] VDD VSS data_latch
XS[31] PRE_B SEL0 SEL0B SEL1 SEL1B SAE WE DL[31] WL[127] WL[126] WL[125] WL[124] WL[123] WL[122] WL[121] WL[120] WL[119] WL[118]
+ WL[117] WL[116] WL[115] WL[114] WL[113] WL[112] WL[111] WL[110] WL[109] WL[108] WL[107] WL[106] WL[105] WL[104] WL[103] WL[102] WL[101]
+ WL[100] WL[99] WL[98] WL[97] WL[96] WL[95] WL[94] WL[93] WL[92] WL[91] WL[90] WL[89] WL[88] WL[87] WL[86] WL[85] WL[84] WL[83] WL[82]
+ WL[81] WL[80] WL[79] WL[78] WL[77] WL[76] WL[75] WL[74] WL[73] WL[72] WL[71] WL[70] WL[69] WL[68] WL[67] WL[66] WL[65] WL[64] WL[63]
+ WL[62] WL[61] WL[60] WL[59] WL[58] WL[57] WL[56] WL[55] WL[54] WL[53] WL[52] WL[51] WL[50] WL[49] WL[48] WL[47] WL[46] WL[45] WL[44]
+ WL[43] WL[42] WL[41] WL[40] WL[39] WL[38] WL[37] WL[36] WL[35] WL[34] WL[33] WL[32] WL[31] WL[30] WL[29] WL[28] WL[27] WL[26] WL[25]
+ WL[24] WL[23] WL[22] WL[21] WL[20] WL[19] WL[18] WL[17] WL[16] WL[15] WL[14] WL[13] WL[12] WL[11] WL[10] WL[9] WL[8] WL[7] WL[6] WL[5]
+ WL[4] WL[3] WL[2] WL[1] WL[0] DOUT[31] DOUTB[31] VDD VSS bit_slice
XS[30] PRE_B SEL0 SEL0B SEL1 SEL1B SAE WE DL[30] WL[127] WL[126] WL[125] WL[124] WL[123] WL[122] WL[121] WL[120] WL[119] WL[118]
+ WL[117] WL[116] WL[115] WL[114] WL[113] WL[112] WL[111] WL[110] WL[109] WL[108] WL[107] WL[106] WL[105] WL[104] WL[103] WL[102] WL[101]
+ WL[100] WL[99] WL[98] WL[97] WL[96] WL[95] WL[94] WL[93] WL[92] WL[91] WL[90] WL[89] WL[88] WL[87] WL[86] WL[85] WL[84] WL[83] WL[82]
+ WL[81] WL[80] WL[79] WL[78] WL[77] WL[76] WL[75] WL[74] WL[73] WL[72] WL[71] WL[70] WL[69] WL[68] WL[67] WL[66] WL[65] WL[64] WL[63]
+ WL[62] WL[61] WL[60] WL[59] WL[58] WL[57] WL[56] WL[55] WL[54] WL[53] WL[52] WL[51] WL[50] WL[49] WL[48] WL[47] WL[46] WL[45] WL[44]
+ WL[43] WL[42] WL[41] WL[40] WL[39] WL[38] WL[37] WL[36] WL[35] WL[34] WL[33] WL[32] WL[31] WL[30] WL[29] WL[28] WL[27] WL[26] WL[25]
+ WL[24] WL[23] WL[22] WL[21] WL[20] WL[19] WL[18] WL[17] WL[16] WL[15] WL[14] WL[13] WL[12] WL[11] WL[10] WL[9] WL[8] WL[7] WL[6] WL[5]
+ WL[4] WL[3] WL[2] WL[1] WL[0] DOUT[30] DOUTB[30] VDD VSS bit_slice
XS[29] PRE_B SEL0 SEL0B SEL1 SEL1B SAE WE DL[29] WL[127] WL[126] WL[125] WL[124] WL[123] WL[122] WL[121] WL[120] WL[119] WL[118]
+ WL[117] WL[116] WL[115] WL[114] WL[113] WL[112] WL[111] WL[110] WL[109] WL[108] WL[107] WL[106] WL[105] WL[104] WL[103] WL[102] WL[101]
+ WL[100] WL[99] WL[98] WL[97] WL[96] WL[95] WL[94] WL[93] WL[92] WL[91] WL[90] WL[89] WL[88] WL[87] WL[86] WL[85] WL[84] WL[83] WL[82]
+ WL[81] WL[80] WL[79] WL[78] WL[77] WL[76] WL[75] WL[74] WL[73] WL[72] WL[71] WL[70] WL[69] WL[68] WL[67] WL[66] WL[65] WL[64] WL[63]
+ WL[62] WL[61] WL[60] WL[59] WL[58] WL[57] WL[56] WL[55] WL[54] WL[53] WL[52] WL[51] WL[50] WL[49] WL[48] WL[47] WL[46] WL[45] WL[44]
+ WL[43] WL[42] WL[41] WL[40] WL[39] WL[38] WL[37] WL[36] WL[35] WL[34] WL[33] WL[32] WL[31] WL[30] WL[29] WL[28] WL[27] WL[26] WL[25]
+ WL[24] WL[23] WL[22] WL[21] WL[20] WL[19] WL[18] WL[17] WL[16] WL[15] WL[14] WL[13] WL[12] WL[11] WL[10] WL[9] WL[8] WL[7] WL[6] WL[5]
+ WL[4] WL[3] WL[2] WL[1] WL[0] DOUT[29] DOUTB[29] VDD VSS bit_slice
XS[28] PRE_B SEL0 SEL0B SEL1 SEL1B SAE WE DL[28] WL[127] WL[126] WL[125] WL[124] WL[123] WL[122] WL[121] WL[120] WL[119] WL[118]
+ WL[117] WL[116] WL[115] WL[114] WL[113] WL[112] WL[111] WL[110] WL[109] WL[108] WL[107] WL[106] WL[105] WL[104] WL[103] WL[102] WL[101]
+ WL[100] WL[99] WL[98] WL[97] WL[96] WL[95] WL[94] WL[93] WL[92] WL[91] WL[90] WL[89] WL[88] WL[87] WL[86] WL[85] WL[84] WL[83] WL[82]
+ WL[81] WL[80] WL[79] WL[78] WL[77] WL[76] WL[75] WL[74] WL[73] WL[72] WL[71] WL[70] WL[69] WL[68] WL[67] WL[66] WL[65] WL[64] WL[63]
+ WL[62] WL[61] WL[60] WL[59] WL[58] WL[57] WL[56] WL[55] WL[54] WL[53] WL[52] WL[51] WL[50] WL[49] WL[48] WL[47] WL[46] WL[45] WL[44]
+ WL[43] WL[42] WL[41] WL[40] WL[39] WL[38] WL[37] WL[36] WL[35] WL[34] WL[33] WL[32] WL[31] WL[30] WL[29] WL[28] WL[27] WL[26] WL[25]
+ WL[24] WL[23] WL[22] WL[21] WL[20] WL[19] WL[18] WL[17] WL[16] WL[15] WL[14] WL[13] WL[12] WL[11] WL[10] WL[9] WL[8] WL[7] WL[6] WL[5]
+ WL[4] WL[3] WL[2] WL[1] WL[0] DOUT[28] DOUTB[28] VDD VSS bit_slice
XS[27] PRE_B SEL0 SEL0B SEL1 SEL1B SAE WE DL[27] WL[127] WL[126] WL[125] WL[124] WL[123] WL[122] WL[121] WL[120] WL[119] WL[118]
+ WL[117] WL[116] WL[115] WL[114] WL[113] WL[112] WL[111] WL[110] WL[109] WL[108] WL[107] WL[106] WL[105] WL[104] WL[103] WL[102] WL[101]
+ WL[100] WL[99] WL[98] WL[97] WL[96] WL[95] WL[94] WL[93] WL[92] WL[91] WL[90] WL[89] WL[88] WL[87] WL[86] WL[85] WL[84] WL[83] WL[82]
+ WL[81] WL[80] WL[79] WL[78] WL[77] WL[76] WL[75] WL[74] WL[73] WL[72] WL[71] WL[70] WL[69] WL[68] WL[67] WL[66] WL[65] WL[64] WL[63]
+ WL[62] WL[61] WL[60] WL[59] WL[58] WL[57] WL[56] WL[55] WL[54] WL[53] WL[52] WL[51] WL[50] WL[49] WL[48] WL[47] WL[46] WL[45] WL[44]
+ WL[43] WL[42] WL[41] WL[40] WL[39] WL[38] WL[37] WL[36] WL[35] WL[34] WL[33] WL[32] WL[31] WL[30] WL[29] WL[28] WL[27] WL[26] WL[25]
+ WL[24] WL[23] WL[22] WL[21] WL[20] WL[19] WL[18] WL[17] WL[16] WL[15] WL[14] WL[13] WL[12] WL[11] WL[10] WL[9] WL[8] WL[7] WL[6] WL[5]
+ WL[4] WL[3] WL[2] WL[1] WL[0] DOUT[27] DOUTB[27] VDD VSS bit_slice
XS[26] PRE_B SEL0 SEL0B SEL1 SEL1B SAE WE DL[26] WL[127] WL[126] WL[125] WL[124] WL[123] WL[122] WL[121] WL[120] WL[119] WL[118]
+ WL[117] WL[116] WL[115] WL[114] WL[113] WL[112] WL[111] WL[110] WL[109] WL[108] WL[107] WL[106] WL[105] WL[104] WL[103] WL[102] WL[101]
+ WL[100] WL[99] WL[98] WL[97] WL[96] WL[95] WL[94] WL[93] WL[92] WL[91] WL[90] WL[89] WL[88] WL[87] WL[86] WL[85] WL[84] WL[83] WL[82]
+ WL[81] WL[80] WL[79] WL[78] WL[77] WL[76] WL[75] WL[74] WL[73] WL[72] WL[71] WL[70] WL[69] WL[68] WL[67] WL[66] WL[65] WL[64] WL[63]
+ WL[62] WL[61] WL[60] WL[59] WL[58] WL[57] WL[56] WL[55] WL[54] WL[53] WL[52] WL[51] WL[50] WL[49] WL[48] WL[47] WL[46] WL[45] WL[44]
+ WL[43] WL[42] WL[41] WL[40] WL[39] WL[38] WL[37] WL[36] WL[35] WL[34] WL[33] WL[32] WL[31] WL[30] WL[29] WL[28] WL[27] WL[26] WL[25]
+ WL[24] WL[23] WL[22] WL[21] WL[20] WL[19] WL[18] WL[17] WL[16] WL[15] WL[14] WL[13] WL[12] WL[11] WL[10] WL[9] WL[8] WL[7] WL[6] WL[5]
+ WL[4] WL[3] WL[2] WL[1] WL[0] DOUT[26] DOUTB[26] VDD VSS bit_slice
XS[25] PRE_B SEL0 SEL0B SEL1 SEL1B SAE WE DL[25] WL[127] WL[126] WL[125] WL[124] WL[123] WL[122] WL[121] WL[120] WL[119] WL[118]
+ WL[117] WL[116] WL[115] WL[114] WL[113] WL[112] WL[111] WL[110] WL[109] WL[108] WL[107] WL[106] WL[105] WL[104] WL[103] WL[102] WL[101]
+ WL[100] WL[99] WL[98] WL[97] WL[96] WL[95] WL[94] WL[93] WL[92] WL[91] WL[90] WL[89] WL[88] WL[87] WL[86] WL[85] WL[84] WL[83] WL[82]
+ WL[81] WL[80] WL[79] WL[78] WL[77] WL[76] WL[75] WL[74] WL[73] WL[72] WL[71] WL[70] WL[69] WL[68] WL[67] WL[66] WL[65] WL[64] WL[63]
+ WL[62] WL[61] WL[60] WL[59] WL[58] WL[57] WL[56] WL[55] WL[54] WL[53] WL[52] WL[51] WL[50] WL[49] WL[48] WL[47] WL[46] WL[45] WL[44]
+ WL[43] WL[42] WL[41] WL[40] WL[39] WL[38] WL[37] WL[36] WL[35] WL[34] WL[33] WL[32] WL[31] WL[30] WL[29] WL[28] WL[27] WL[26] WL[25]
+ WL[24] WL[23] WL[22] WL[21] WL[20] WL[19] WL[18] WL[17] WL[16] WL[15] WL[14] WL[13] WL[12] WL[11] WL[10] WL[9] WL[8] WL[7] WL[6] WL[5]
+ WL[4] WL[3] WL[2] WL[1] WL[0] DOUT[25] DOUTB[25] VDD VSS bit_slice
XS[24] PRE_B SEL0 SEL0B SEL1 SEL1B SAE WE DL[24] WL[127] WL[126] WL[125] WL[124] WL[123] WL[122] WL[121] WL[120] WL[119] WL[118]
+ WL[117] WL[116] WL[115] WL[114] WL[113] WL[112] WL[111] WL[110] WL[109] WL[108] WL[107] WL[106] WL[105] WL[104] WL[103] WL[102] WL[101]
+ WL[100] WL[99] WL[98] WL[97] WL[96] WL[95] WL[94] WL[93] WL[92] WL[91] WL[90] WL[89] WL[88] WL[87] WL[86] WL[85] WL[84] WL[83] WL[82]
+ WL[81] WL[80] WL[79] WL[78] WL[77] WL[76] WL[75] WL[74] WL[73] WL[72] WL[71] WL[70] WL[69] WL[68] WL[67] WL[66] WL[65] WL[64] WL[63]
+ WL[62] WL[61] WL[60] WL[59] WL[58] WL[57] WL[56] WL[55] WL[54] WL[53] WL[52] WL[51] WL[50] WL[49] WL[48] WL[47] WL[46] WL[45] WL[44]
+ WL[43] WL[42] WL[41] WL[40] WL[39] WL[38] WL[37] WL[36] WL[35] WL[34] WL[33] WL[32] WL[31] WL[30] WL[29] WL[28] WL[27] WL[26] WL[25]
+ WL[24] WL[23] WL[22] WL[21] WL[20] WL[19] WL[18] WL[17] WL[16] WL[15] WL[14] WL[13] WL[12] WL[11] WL[10] WL[9] WL[8] WL[7] WL[6] WL[5]
+ WL[4] WL[3] WL[2] WL[1] WL[0] DOUT[24] DOUTB[24] VDD VSS bit_slice
XS[23] PRE_B SEL0 SEL0B SEL1 SEL1B SAE WE DL[23] WL[127] WL[126] WL[125] WL[124] WL[123] WL[122] WL[121] WL[120] WL[119] WL[118]
+ WL[117] WL[116] WL[115] WL[114] WL[113] WL[112] WL[111] WL[110] WL[109] WL[108] WL[107] WL[106] WL[105] WL[104] WL[103] WL[102] WL[101]
+ WL[100] WL[99] WL[98] WL[97] WL[96] WL[95] WL[94] WL[93] WL[92] WL[91] WL[90] WL[89] WL[88] WL[87] WL[86] WL[85] WL[84] WL[83] WL[82]
+ WL[81] WL[80] WL[79] WL[78] WL[77] WL[76] WL[75] WL[74] WL[73] WL[72] WL[71] WL[70] WL[69] WL[68] WL[67] WL[66] WL[65] WL[64] WL[63]
+ WL[62] WL[61] WL[60] WL[59] WL[58] WL[57] WL[56] WL[55] WL[54] WL[53] WL[52] WL[51] WL[50] WL[49] WL[48] WL[47] WL[46] WL[45] WL[44]
+ WL[43] WL[42] WL[41] WL[40] WL[39] WL[38] WL[37] WL[36] WL[35] WL[34] WL[33] WL[32] WL[31] WL[30] WL[29] WL[28] WL[27] WL[26] WL[25]
+ WL[24] WL[23] WL[22] WL[21] WL[20] WL[19] WL[18] WL[17] WL[16] WL[15] WL[14] WL[13] WL[12] WL[11] WL[10] WL[9] WL[8] WL[7] WL[6] WL[5]
+ WL[4] WL[3] WL[2] WL[1] WL[0] DOUT[23] DOUTB[23] VDD VSS bit_slice
XS[22] PRE_B SEL0 SEL0B SEL1 SEL1B SAE WE DL[22] WL[127] WL[126] WL[125] WL[124] WL[123] WL[122] WL[121] WL[120] WL[119] WL[118]
+ WL[117] WL[116] WL[115] WL[114] WL[113] WL[112] WL[111] WL[110] WL[109] WL[108] WL[107] WL[106] WL[105] WL[104] WL[103] WL[102] WL[101]
+ WL[100] WL[99] WL[98] WL[97] WL[96] WL[95] WL[94] WL[93] WL[92] WL[91] WL[90] WL[89] WL[88] WL[87] WL[86] WL[85] WL[84] WL[83] WL[82]
+ WL[81] WL[80] WL[79] WL[78] WL[77] WL[76] WL[75] WL[74] WL[73] WL[72] WL[71] WL[70] WL[69] WL[68] WL[67] WL[66] WL[65] WL[64] WL[63]
+ WL[62] WL[61] WL[60] WL[59] WL[58] WL[57] WL[56] WL[55] WL[54] WL[53] WL[52] WL[51] WL[50] WL[49] WL[48] WL[47] WL[46] WL[45] WL[44]
+ WL[43] WL[42] WL[41] WL[40] WL[39] WL[38] WL[37] WL[36] WL[35] WL[34] WL[33] WL[32] WL[31] WL[30] WL[29] WL[28] WL[27] WL[26] WL[25]
+ WL[24] WL[23] WL[22] WL[21] WL[20] WL[19] WL[18] WL[17] WL[16] WL[15] WL[14] WL[13] WL[12] WL[11] WL[10] WL[9] WL[8] WL[7] WL[6] WL[5]
+ WL[4] WL[3] WL[2] WL[1] WL[0] DOUT[22] DOUTB[22] VDD VSS bit_slice
XS[21] PRE_B SEL0 SEL0B SEL1 SEL1B SAE WE DL[21] WL[127] WL[126] WL[125] WL[124] WL[123] WL[122] WL[121] WL[120] WL[119] WL[118]
+ WL[117] WL[116] WL[115] WL[114] WL[113] WL[112] WL[111] WL[110] WL[109] WL[108] WL[107] WL[106] WL[105] WL[104] WL[103] WL[102] WL[101]
+ WL[100] WL[99] WL[98] WL[97] WL[96] WL[95] WL[94] WL[93] WL[92] WL[91] WL[90] WL[89] WL[88] WL[87] WL[86] WL[85] WL[84] WL[83] WL[82]
+ WL[81] WL[80] WL[79] WL[78] WL[77] WL[76] WL[75] WL[74] WL[73] WL[72] WL[71] WL[70] WL[69] WL[68] WL[67] WL[66] WL[65] WL[64] WL[63]
+ WL[62] WL[61] WL[60] WL[59] WL[58] WL[57] WL[56] WL[55] WL[54] WL[53] WL[52] WL[51] WL[50] WL[49] WL[48] WL[47] WL[46] WL[45] WL[44]
+ WL[43] WL[42] WL[41] WL[40] WL[39] WL[38] WL[37] WL[36] WL[35] WL[34] WL[33] WL[32] WL[31] WL[30] WL[29] WL[28] WL[27] WL[26] WL[25]
+ WL[24] WL[23] WL[22] WL[21] WL[20] WL[19] WL[18] WL[17] WL[16] WL[15] WL[14] WL[13] WL[12] WL[11] WL[10] WL[9] WL[8] WL[7] WL[6] WL[5]
+ WL[4] WL[3] WL[2] WL[1] WL[0] DOUT[21] DOUTB[21] VDD VSS bit_slice
XS[20] PRE_B SEL0 SEL0B SEL1 SEL1B SAE WE DL[20] WL[127] WL[126] WL[125] WL[124] WL[123] WL[122] WL[121] WL[120] WL[119] WL[118]
+ WL[117] WL[116] WL[115] WL[114] WL[113] WL[112] WL[111] WL[110] WL[109] WL[108] WL[107] WL[106] WL[105] WL[104] WL[103] WL[102] WL[101]
+ WL[100] WL[99] WL[98] WL[97] WL[96] WL[95] WL[94] WL[93] WL[92] WL[91] WL[90] WL[89] WL[88] WL[87] WL[86] WL[85] WL[84] WL[83] WL[82]
+ WL[81] WL[80] WL[79] WL[78] WL[77] WL[76] WL[75] WL[74] WL[73] WL[72] WL[71] WL[70] WL[69] WL[68] WL[67] WL[66] WL[65] WL[64] WL[63]
+ WL[62] WL[61] WL[60] WL[59] WL[58] WL[57] WL[56] WL[55] WL[54] WL[53] WL[52] WL[51] WL[50] WL[49] WL[48] WL[47] WL[46] WL[45] WL[44]
+ WL[43] WL[42] WL[41] WL[40] WL[39] WL[38] WL[37] WL[36] WL[35] WL[34] WL[33] WL[32] WL[31] WL[30] WL[29] WL[28] WL[27] WL[26] WL[25]
+ WL[24] WL[23] WL[22] WL[21] WL[20] WL[19] WL[18] WL[17] WL[16] WL[15] WL[14] WL[13] WL[12] WL[11] WL[10] WL[9] WL[8] WL[7] WL[6] WL[5]
+ WL[4] WL[3] WL[2] WL[1] WL[0] DOUT[20] DOUTB[20] VDD VSS bit_slice
XS[19] PRE_B SEL0 SEL0B SEL1 SEL1B SAE WE DL[19] WL[127] WL[126] WL[125] WL[124] WL[123] WL[122] WL[121] WL[120] WL[119] WL[118]
+ WL[117] WL[116] WL[115] WL[114] WL[113] WL[112] WL[111] WL[110] WL[109] WL[108] WL[107] WL[106] WL[105] WL[104] WL[103] WL[102] WL[101]
+ WL[100] WL[99] WL[98] WL[97] WL[96] WL[95] WL[94] WL[93] WL[92] WL[91] WL[90] WL[89] WL[88] WL[87] WL[86] WL[85] WL[84] WL[83] WL[82]
+ WL[81] WL[80] WL[79] WL[78] WL[77] WL[76] WL[75] WL[74] WL[73] WL[72] WL[71] WL[70] WL[69] WL[68] WL[67] WL[66] WL[65] WL[64] WL[63]
+ WL[62] WL[61] WL[60] WL[59] WL[58] WL[57] WL[56] WL[55] WL[54] WL[53] WL[52] WL[51] WL[50] WL[49] WL[48] WL[47] WL[46] WL[45] WL[44]
+ WL[43] WL[42] WL[41] WL[40] WL[39] WL[38] WL[37] WL[36] WL[35] WL[34] WL[33] WL[32] WL[31] WL[30] WL[29] WL[28] WL[27] WL[26] WL[25]
+ WL[24] WL[23] WL[22] WL[21] WL[20] WL[19] WL[18] WL[17] WL[16] WL[15] WL[14] WL[13] WL[12] WL[11] WL[10] WL[9] WL[8] WL[7] WL[6] WL[5]
+ WL[4] WL[3] WL[2] WL[1] WL[0] DOUT[19] DOUTB[19] VDD VSS bit_slice
XS[18] PRE_B SEL0 SEL0B SEL1 SEL1B SAE WE DL[18] WL[127] WL[126] WL[125] WL[124] WL[123] WL[122] WL[121] WL[120] WL[119] WL[118]
+ WL[117] WL[116] WL[115] WL[114] WL[113] WL[112] WL[111] WL[110] WL[109] WL[108] WL[107] WL[106] WL[105] WL[104] WL[103] WL[102] WL[101]
+ WL[100] WL[99] WL[98] WL[97] WL[96] WL[95] WL[94] WL[93] WL[92] WL[91] WL[90] WL[89] WL[88] WL[87] WL[86] WL[85] WL[84] WL[83] WL[82]
+ WL[81] WL[80] WL[79] WL[78] WL[77] WL[76] WL[75] WL[74] WL[73] WL[72] WL[71] WL[70] WL[69] WL[68] WL[67] WL[66] WL[65] WL[64] WL[63]
+ WL[62] WL[61] WL[60] WL[59] WL[58] WL[57] WL[56] WL[55] WL[54] WL[53] WL[52] WL[51] WL[50] WL[49] WL[48] WL[47] WL[46] WL[45] WL[44]
+ WL[43] WL[42] WL[41] WL[40] WL[39] WL[38] WL[37] WL[36] WL[35] WL[34] WL[33] WL[32] WL[31] WL[30] WL[29] WL[28] WL[27] WL[26] WL[25]
+ WL[24] WL[23] WL[22] WL[21] WL[20] WL[19] WL[18] WL[17] WL[16] WL[15] WL[14] WL[13] WL[12] WL[11] WL[10] WL[9] WL[8] WL[7] WL[6] WL[5]
+ WL[4] WL[3] WL[2] WL[1] WL[0] DOUT[18] DOUTB[18] VDD VSS bit_slice
XS[17] PRE_B SEL0 SEL0B SEL1 SEL1B SAE WE DL[17] WL[127] WL[126] WL[125] WL[124] WL[123] WL[122] WL[121] WL[120] WL[119] WL[118]
+ WL[117] WL[116] WL[115] WL[114] WL[113] WL[112] WL[111] WL[110] WL[109] WL[108] WL[107] WL[106] WL[105] WL[104] WL[103] WL[102] WL[101]
+ WL[100] WL[99] WL[98] WL[97] WL[96] WL[95] WL[94] WL[93] WL[92] WL[91] WL[90] WL[89] WL[88] WL[87] WL[86] WL[85] WL[84] WL[83] WL[82]
+ WL[81] WL[80] WL[79] WL[78] WL[77] WL[76] WL[75] WL[74] WL[73] WL[72] WL[71] WL[70] WL[69] WL[68] WL[67] WL[66] WL[65] WL[64] WL[63]
+ WL[62] WL[61] WL[60] WL[59] WL[58] WL[57] WL[56] WL[55] WL[54] WL[53] WL[52] WL[51] WL[50] WL[49] WL[48] WL[47] WL[46] WL[45] WL[44]
+ WL[43] WL[42] WL[41] WL[40] WL[39] WL[38] WL[37] WL[36] WL[35] WL[34] WL[33] WL[32] WL[31] WL[30] WL[29] WL[28] WL[27] WL[26] WL[25]
+ WL[24] WL[23] WL[22] WL[21] WL[20] WL[19] WL[18] WL[17] WL[16] WL[15] WL[14] WL[13] WL[12] WL[11] WL[10] WL[9] WL[8] WL[7] WL[6] WL[5]
+ WL[4] WL[3] WL[2] WL[1] WL[0] DOUT[17] DOUTB[17] VDD VSS bit_slice
XS[16] PRE_B SEL0 SEL0B SEL1 SEL1B SAE WE DL[16] WL[127] WL[126] WL[125] WL[124] WL[123] WL[122] WL[121] WL[120] WL[119] WL[118]
+ WL[117] WL[116] WL[115] WL[114] WL[113] WL[112] WL[111] WL[110] WL[109] WL[108] WL[107] WL[106] WL[105] WL[104] WL[103] WL[102] WL[101]
+ WL[100] WL[99] WL[98] WL[97] WL[96] WL[95] WL[94] WL[93] WL[92] WL[91] WL[90] WL[89] WL[88] WL[87] WL[86] WL[85] WL[84] WL[83] WL[82]
+ WL[81] WL[80] WL[79] WL[78] WL[77] WL[76] WL[75] WL[74] WL[73] WL[72] WL[71] WL[70] WL[69] WL[68] WL[67] WL[66] WL[65] WL[64] WL[63]
+ WL[62] WL[61] WL[60] WL[59] WL[58] WL[57] WL[56] WL[55] WL[54] WL[53] WL[52] WL[51] WL[50] WL[49] WL[48] WL[47] WL[46] WL[45] WL[44]
+ WL[43] WL[42] WL[41] WL[40] WL[39] WL[38] WL[37] WL[36] WL[35] WL[34] WL[33] WL[32] WL[31] WL[30] WL[29] WL[28] WL[27] WL[26] WL[25]
+ WL[24] WL[23] WL[22] WL[21] WL[20] WL[19] WL[18] WL[17] WL[16] WL[15] WL[14] WL[13] WL[12] WL[11] WL[10] WL[9] WL[8] WL[7] WL[6] WL[5]
+ WL[4] WL[3] WL[2] WL[1] WL[0] DOUT[16] DOUTB[16] VDD VSS bit_slice
XS[15] PRE_B SEL0 SEL0B SEL1 SEL1B SAE WE DL[15] WL[127] WL[126] WL[125] WL[124] WL[123] WL[122] WL[121] WL[120] WL[119] WL[118]
+ WL[117] WL[116] WL[115] WL[114] WL[113] WL[112] WL[111] WL[110] WL[109] WL[108] WL[107] WL[106] WL[105] WL[104] WL[103] WL[102] WL[101]
+ WL[100] WL[99] WL[98] WL[97] WL[96] WL[95] WL[94] WL[93] WL[92] WL[91] WL[90] WL[89] WL[88] WL[87] WL[86] WL[85] WL[84] WL[83] WL[82]
+ WL[81] WL[80] WL[79] WL[78] WL[77] WL[76] WL[75] WL[74] WL[73] WL[72] WL[71] WL[70] WL[69] WL[68] WL[67] WL[66] WL[65] WL[64] WL[63]
+ WL[62] WL[61] WL[60] WL[59] WL[58] WL[57] WL[56] WL[55] WL[54] WL[53] WL[52] WL[51] WL[50] WL[49] WL[48] WL[47] WL[46] WL[45] WL[44]
+ WL[43] WL[42] WL[41] WL[40] WL[39] WL[38] WL[37] WL[36] WL[35] WL[34] WL[33] WL[32] WL[31] WL[30] WL[29] WL[28] WL[27] WL[26] WL[25]
+ WL[24] WL[23] WL[22] WL[21] WL[20] WL[19] WL[18] WL[17] WL[16] WL[15] WL[14] WL[13] WL[12] WL[11] WL[10] WL[9] WL[8] WL[7] WL[6] WL[5]
+ WL[4] WL[3] WL[2] WL[1] WL[0] DOUT[15] DOUTB[15] VDD VSS bit_slice
XS[14] PRE_B SEL0 SEL0B SEL1 SEL1B SAE WE DL[14] WL[127] WL[126] WL[125] WL[124] WL[123] WL[122] WL[121] WL[120] WL[119] WL[118]
+ WL[117] WL[116] WL[115] WL[114] WL[113] WL[112] WL[111] WL[110] WL[109] WL[108] WL[107] WL[106] WL[105] WL[104] WL[103] WL[102] WL[101]
+ WL[100] WL[99] WL[98] WL[97] WL[96] WL[95] WL[94] WL[93] WL[92] WL[91] WL[90] WL[89] WL[88] WL[87] WL[86] WL[85] WL[84] WL[83] WL[82]
+ WL[81] WL[80] WL[79] WL[78] WL[77] WL[76] WL[75] WL[74] WL[73] WL[72] WL[71] WL[70] WL[69] WL[68] WL[67] WL[66] WL[65] WL[64] WL[63]
+ WL[62] WL[61] WL[60] WL[59] WL[58] WL[57] WL[56] WL[55] WL[54] WL[53] WL[52] WL[51] WL[50] WL[49] WL[48] WL[47] WL[46] WL[45] WL[44]
+ WL[43] WL[42] WL[41] WL[40] WL[39] WL[38] WL[37] WL[36] WL[35] WL[34] WL[33] WL[32] WL[31] WL[30] WL[29] WL[28] WL[27] WL[26] WL[25]
+ WL[24] WL[23] WL[22] WL[21] WL[20] WL[19] WL[18] WL[17] WL[16] WL[15] WL[14] WL[13] WL[12] WL[11] WL[10] WL[9] WL[8] WL[7] WL[6] WL[5]
+ WL[4] WL[3] WL[2] WL[1] WL[0] DOUT[14] DOUTB[14] VDD VSS bit_slice
XS[13] PRE_B SEL0 SEL0B SEL1 SEL1B SAE WE DL[13] WL[127] WL[126] WL[125] WL[124] WL[123] WL[122] WL[121] WL[120] WL[119] WL[118]
+ WL[117] WL[116] WL[115] WL[114] WL[113] WL[112] WL[111] WL[110] WL[109] WL[108] WL[107] WL[106] WL[105] WL[104] WL[103] WL[102] WL[101]
+ WL[100] WL[99] WL[98] WL[97] WL[96] WL[95] WL[94] WL[93] WL[92] WL[91] WL[90] WL[89] WL[88] WL[87] WL[86] WL[85] WL[84] WL[83] WL[82]
+ WL[81] WL[80] WL[79] WL[78] WL[77] WL[76] WL[75] WL[74] WL[73] WL[72] WL[71] WL[70] WL[69] WL[68] WL[67] WL[66] WL[65] WL[64] WL[63]
+ WL[62] WL[61] WL[60] WL[59] WL[58] WL[57] WL[56] WL[55] WL[54] WL[53] WL[52] WL[51] WL[50] WL[49] WL[48] WL[47] WL[46] WL[45] WL[44]
+ WL[43] WL[42] WL[41] WL[40] WL[39] WL[38] WL[37] WL[36] WL[35] WL[34] WL[33] WL[32] WL[31] WL[30] WL[29] WL[28] WL[27] WL[26] WL[25]
+ WL[24] WL[23] WL[22] WL[21] WL[20] WL[19] WL[18] WL[17] WL[16] WL[15] WL[14] WL[13] WL[12] WL[11] WL[10] WL[9] WL[8] WL[7] WL[6] WL[5]
+ WL[4] WL[3] WL[2] WL[1] WL[0] DOUT[13] DOUTB[13] VDD VSS bit_slice
XS[12] PRE_B SEL0 SEL0B SEL1 SEL1B SAE WE DL[12] WL[127] WL[126] WL[125] WL[124] WL[123] WL[122] WL[121] WL[120] WL[119] WL[118]
+ WL[117] WL[116] WL[115] WL[114] WL[113] WL[112] WL[111] WL[110] WL[109] WL[108] WL[107] WL[106] WL[105] WL[104] WL[103] WL[102] WL[101]
+ WL[100] WL[99] WL[98] WL[97] WL[96] WL[95] WL[94] WL[93] WL[92] WL[91] WL[90] WL[89] WL[88] WL[87] WL[86] WL[85] WL[84] WL[83] WL[82]
+ WL[81] WL[80] WL[79] WL[78] WL[77] WL[76] WL[75] WL[74] WL[73] WL[72] WL[71] WL[70] WL[69] WL[68] WL[67] WL[66] WL[65] WL[64] WL[63]
+ WL[62] WL[61] WL[60] WL[59] WL[58] WL[57] WL[56] WL[55] WL[54] WL[53] WL[52] WL[51] WL[50] WL[49] WL[48] WL[47] WL[46] WL[45] WL[44]
+ WL[43] WL[42] WL[41] WL[40] WL[39] WL[38] WL[37] WL[36] WL[35] WL[34] WL[33] WL[32] WL[31] WL[30] WL[29] WL[28] WL[27] WL[26] WL[25]
+ WL[24] WL[23] WL[22] WL[21] WL[20] WL[19] WL[18] WL[17] WL[16] WL[15] WL[14] WL[13] WL[12] WL[11] WL[10] WL[9] WL[8] WL[7] WL[6] WL[5]
+ WL[4] WL[3] WL[2] WL[1] WL[0] DOUT[12] DOUTB[12] VDD VSS bit_slice
XS[11] PRE_B SEL0 SEL0B SEL1 SEL1B SAE WE DL[11] WL[127] WL[126] WL[125] WL[124] WL[123] WL[122] WL[121] WL[120] WL[119] WL[118]
+ WL[117] WL[116] WL[115] WL[114] WL[113] WL[112] WL[111] WL[110] WL[109] WL[108] WL[107] WL[106] WL[105] WL[104] WL[103] WL[102] WL[101]
+ WL[100] WL[99] WL[98] WL[97] WL[96] WL[95] WL[94] WL[93] WL[92] WL[91] WL[90] WL[89] WL[88] WL[87] WL[86] WL[85] WL[84] WL[83] WL[82]
+ WL[81] WL[80] WL[79] WL[78] WL[77] WL[76] WL[75] WL[74] WL[73] WL[72] WL[71] WL[70] WL[69] WL[68] WL[67] WL[66] WL[65] WL[64] WL[63]
+ WL[62] WL[61] WL[60] WL[59] WL[58] WL[57] WL[56] WL[55] WL[54] WL[53] WL[52] WL[51] WL[50] WL[49] WL[48] WL[47] WL[46] WL[45] WL[44]
+ WL[43] WL[42] WL[41] WL[40] WL[39] WL[38] WL[37] WL[36] WL[35] WL[34] WL[33] WL[32] WL[31] WL[30] WL[29] WL[28] WL[27] WL[26] WL[25]
+ WL[24] WL[23] WL[22] WL[21] WL[20] WL[19] WL[18] WL[17] WL[16] WL[15] WL[14] WL[13] WL[12] WL[11] WL[10] WL[9] WL[8] WL[7] WL[6] WL[5]
+ WL[4] WL[3] WL[2] WL[1] WL[0] DOUT[11] DOUTB[11] VDD VSS bit_slice
XS[10] PRE_B SEL0 SEL0B SEL1 SEL1B SAE WE DL[10] WL[127] WL[126] WL[125] WL[124] WL[123] WL[122] WL[121] WL[120] WL[119] WL[118]
+ WL[117] WL[116] WL[115] WL[114] WL[113] WL[112] WL[111] WL[110] WL[109] WL[108] WL[107] WL[106] WL[105] WL[104] WL[103] WL[102] WL[101]
+ WL[100] WL[99] WL[98] WL[97] WL[96] WL[95] WL[94] WL[93] WL[92] WL[91] WL[90] WL[89] WL[88] WL[87] WL[86] WL[85] WL[84] WL[83] WL[82]
+ WL[81] WL[80] WL[79] WL[78] WL[77] WL[76] WL[75] WL[74] WL[73] WL[72] WL[71] WL[70] WL[69] WL[68] WL[67] WL[66] WL[65] WL[64] WL[63]
+ WL[62] WL[61] WL[60] WL[59] WL[58] WL[57] WL[56] WL[55] WL[54] WL[53] WL[52] WL[51] WL[50] WL[49] WL[48] WL[47] WL[46] WL[45] WL[44]
+ WL[43] WL[42] WL[41] WL[40] WL[39] WL[38] WL[37] WL[36] WL[35] WL[34] WL[33] WL[32] WL[31] WL[30] WL[29] WL[28] WL[27] WL[26] WL[25]
+ WL[24] WL[23] WL[22] WL[21] WL[20] WL[19] WL[18] WL[17] WL[16] WL[15] WL[14] WL[13] WL[12] WL[11] WL[10] WL[9] WL[8] WL[7] WL[6] WL[5]
+ WL[4] WL[3] WL[2] WL[1] WL[0] DOUT[10] DOUTB[10] VDD VSS bit_slice
XS[9] PRE_B SEL0 SEL0B SEL1 SEL1B SAE WE DL[9] WL[127] WL[126] WL[125] WL[124] WL[123] WL[122] WL[121] WL[120] WL[119] WL[118]
+ WL[117] WL[116] WL[115] WL[114] WL[113] WL[112] WL[111] WL[110] WL[109] WL[108] WL[107] WL[106] WL[105] WL[104] WL[103] WL[102] WL[101]
+ WL[100] WL[99] WL[98] WL[97] WL[96] WL[95] WL[94] WL[93] WL[92] WL[91] WL[90] WL[89] WL[88] WL[87] WL[86] WL[85] WL[84] WL[83] WL[82]
+ WL[81] WL[80] WL[79] WL[78] WL[77] WL[76] WL[75] WL[74] WL[73] WL[72] WL[71] WL[70] WL[69] WL[68] WL[67] WL[66] WL[65] WL[64] WL[63]
+ WL[62] WL[61] WL[60] WL[59] WL[58] WL[57] WL[56] WL[55] WL[54] WL[53] WL[52] WL[51] WL[50] WL[49] WL[48] WL[47] WL[46] WL[45] WL[44]
+ WL[43] WL[42] WL[41] WL[40] WL[39] WL[38] WL[37] WL[36] WL[35] WL[34] WL[33] WL[32] WL[31] WL[30] WL[29] WL[28] WL[27] WL[26] WL[25]
+ WL[24] WL[23] WL[22] WL[21] WL[20] WL[19] WL[18] WL[17] WL[16] WL[15] WL[14] WL[13] WL[12] WL[11] WL[10] WL[9] WL[8] WL[7] WL[6] WL[5]
+ WL[4] WL[3] WL[2] WL[1] WL[0] DOUT[9] DOUTB[9] VDD VSS bit_slice
XS[8] PRE_B SEL0 SEL0B SEL1 SEL1B SAE WE DL[8] WL[127] WL[126] WL[125] WL[124] WL[123] WL[122] WL[121] WL[120] WL[119] WL[118]
+ WL[117] WL[116] WL[115] WL[114] WL[113] WL[112] WL[111] WL[110] WL[109] WL[108] WL[107] WL[106] WL[105] WL[104] WL[103] WL[102] WL[101]
+ WL[100] WL[99] WL[98] WL[97] WL[96] WL[95] WL[94] WL[93] WL[92] WL[91] WL[90] WL[89] WL[88] WL[87] WL[86] WL[85] WL[84] WL[83] WL[82]
+ WL[81] WL[80] WL[79] WL[78] WL[77] WL[76] WL[75] WL[74] WL[73] WL[72] WL[71] WL[70] WL[69] WL[68] WL[67] WL[66] WL[65] WL[64] WL[63]
+ WL[62] WL[61] WL[60] WL[59] WL[58] WL[57] WL[56] WL[55] WL[54] WL[53] WL[52] WL[51] WL[50] WL[49] WL[48] WL[47] WL[46] WL[45] WL[44]
+ WL[43] WL[42] WL[41] WL[40] WL[39] WL[38] WL[37] WL[36] WL[35] WL[34] WL[33] WL[32] WL[31] WL[30] WL[29] WL[28] WL[27] WL[26] WL[25]
+ WL[24] WL[23] WL[22] WL[21] WL[20] WL[19] WL[18] WL[17] WL[16] WL[15] WL[14] WL[13] WL[12] WL[11] WL[10] WL[9] WL[8] WL[7] WL[6] WL[5]
+ WL[4] WL[3] WL[2] WL[1] WL[0] DOUT[8] DOUTB[8] VDD VSS bit_slice
XS[7] PRE_B SEL0 SEL0B SEL1 SEL1B SAE WE DL[7] WL[127] WL[126] WL[125] WL[124] WL[123] WL[122] WL[121] WL[120] WL[119] WL[118]
+ WL[117] WL[116] WL[115] WL[114] WL[113] WL[112] WL[111] WL[110] WL[109] WL[108] WL[107] WL[106] WL[105] WL[104] WL[103] WL[102] WL[101]
+ WL[100] WL[99] WL[98] WL[97] WL[96] WL[95] WL[94] WL[93] WL[92] WL[91] WL[90] WL[89] WL[88] WL[87] WL[86] WL[85] WL[84] WL[83] WL[82]
+ WL[81] WL[80] WL[79] WL[78] WL[77] WL[76] WL[75] WL[74] WL[73] WL[72] WL[71] WL[70] WL[69] WL[68] WL[67] WL[66] WL[65] WL[64] WL[63]
+ WL[62] WL[61] WL[60] WL[59] WL[58] WL[57] WL[56] WL[55] WL[54] WL[53] WL[52] WL[51] WL[50] WL[49] WL[48] WL[47] WL[46] WL[45] WL[44]
+ WL[43] WL[42] WL[41] WL[40] WL[39] WL[38] WL[37] WL[36] WL[35] WL[34] WL[33] WL[32] WL[31] WL[30] WL[29] WL[28] WL[27] WL[26] WL[25]
+ WL[24] WL[23] WL[22] WL[21] WL[20] WL[19] WL[18] WL[17] WL[16] WL[15] WL[14] WL[13] WL[12] WL[11] WL[10] WL[9] WL[8] WL[7] WL[6] WL[5]
+ WL[4] WL[3] WL[2] WL[1] WL[0] DOUT[7] DOUTB[7] VDD VSS bit_slice
XS[6] PRE_B SEL0 SEL0B SEL1 SEL1B SAE WE DL[6] WL[127] WL[126] WL[125] WL[124] WL[123] WL[122] WL[121] WL[120] WL[119] WL[118]
+ WL[117] WL[116] WL[115] WL[114] WL[113] WL[112] WL[111] WL[110] WL[109] WL[108] WL[107] WL[106] WL[105] WL[104] WL[103] WL[102] WL[101]
+ WL[100] WL[99] WL[98] WL[97] WL[96] WL[95] WL[94] WL[93] WL[92] WL[91] WL[90] WL[89] WL[88] WL[87] WL[86] WL[85] WL[84] WL[83] WL[82]
+ WL[81] WL[80] WL[79] WL[78] WL[77] WL[76] WL[75] WL[74] WL[73] WL[72] WL[71] WL[70] WL[69] WL[68] WL[67] WL[66] WL[65] WL[64] WL[63]
+ WL[62] WL[61] WL[60] WL[59] WL[58] WL[57] WL[56] WL[55] WL[54] WL[53] WL[52] WL[51] WL[50] WL[49] WL[48] WL[47] WL[46] WL[45] WL[44]
+ WL[43] WL[42] WL[41] WL[40] WL[39] WL[38] WL[37] WL[36] WL[35] WL[34] WL[33] WL[32] WL[31] WL[30] WL[29] WL[28] WL[27] WL[26] WL[25]
+ WL[24] WL[23] WL[22] WL[21] WL[20] WL[19] WL[18] WL[17] WL[16] WL[15] WL[14] WL[13] WL[12] WL[11] WL[10] WL[9] WL[8] WL[7] WL[6] WL[5]
+ WL[4] WL[3] WL[2] WL[1] WL[0] DOUT[6] DOUTB[6] VDD VSS bit_slice
XS[5] PRE_B SEL0 SEL0B SEL1 SEL1B SAE WE DL[5] WL[127] WL[126] WL[125] WL[124] WL[123] WL[122] WL[121] WL[120] WL[119] WL[118]
+ WL[117] WL[116] WL[115] WL[114] WL[113] WL[112] WL[111] WL[110] WL[109] WL[108] WL[107] WL[106] WL[105] WL[104] WL[103] WL[102] WL[101]
+ WL[100] WL[99] WL[98] WL[97] WL[96] WL[95] WL[94] WL[93] WL[92] WL[91] WL[90] WL[89] WL[88] WL[87] WL[86] WL[85] WL[84] WL[83] WL[82]
+ WL[81] WL[80] WL[79] WL[78] WL[77] WL[76] WL[75] WL[74] WL[73] WL[72] WL[71] WL[70] WL[69] WL[68] WL[67] WL[66] WL[65] WL[64] WL[63]
+ WL[62] WL[61] WL[60] WL[59] WL[58] WL[57] WL[56] WL[55] WL[54] WL[53] WL[52] WL[51] WL[50] WL[49] WL[48] WL[47] WL[46] WL[45] WL[44]
+ WL[43] WL[42] WL[41] WL[40] WL[39] WL[38] WL[37] WL[36] WL[35] WL[34] WL[33] WL[32] WL[31] WL[30] WL[29] WL[28] WL[27] WL[26] WL[25]
+ WL[24] WL[23] WL[22] WL[21] WL[20] WL[19] WL[18] WL[17] WL[16] WL[15] WL[14] WL[13] WL[12] WL[11] WL[10] WL[9] WL[8] WL[7] WL[6] WL[5]
+ WL[4] WL[3] WL[2] WL[1] WL[0] DOUT[5] DOUTB[5] VDD VSS bit_slice
XS[4] PRE_B SEL0 SEL0B SEL1 SEL1B SAE WE DL[4] WL[127] WL[126] WL[125] WL[124] WL[123] WL[122] WL[121] WL[120] WL[119] WL[118]
+ WL[117] WL[116] WL[115] WL[114] WL[113] WL[112] WL[111] WL[110] WL[109] WL[108] WL[107] WL[106] WL[105] WL[104] WL[103] WL[102] WL[101]
+ WL[100] WL[99] WL[98] WL[97] WL[96] WL[95] WL[94] WL[93] WL[92] WL[91] WL[90] WL[89] WL[88] WL[87] WL[86] WL[85] WL[84] WL[83] WL[82]
+ WL[81] WL[80] WL[79] WL[78] WL[77] WL[76] WL[75] WL[74] WL[73] WL[72] WL[71] WL[70] WL[69] WL[68] WL[67] WL[66] WL[65] WL[64] WL[63]
+ WL[62] WL[61] WL[60] WL[59] WL[58] WL[57] WL[56] WL[55] WL[54] WL[53] WL[52] WL[51] WL[50] WL[49] WL[48] WL[47] WL[46] WL[45] WL[44]
+ WL[43] WL[42] WL[41] WL[40] WL[39] WL[38] WL[37] WL[36] WL[35] WL[34] WL[33] WL[32] WL[31] WL[30] WL[29] WL[28] WL[27] WL[26] WL[25]
+ WL[24] WL[23] WL[22] WL[21] WL[20] WL[19] WL[18] WL[17] WL[16] WL[15] WL[14] WL[13] WL[12] WL[11] WL[10] WL[9] WL[8] WL[7] WL[6] WL[5]
+ WL[4] WL[3] WL[2] WL[1] WL[0] DOUT[4] DOUTB[4] VDD VSS bit_slice
XS[3] PRE_B SEL0 SEL0B SEL1 SEL1B SAE WE DL[3] WL[127] WL[126] WL[125] WL[124] WL[123] WL[122] WL[121] WL[120] WL[119] WL[118]
+ WL[117] WL[116] WL[115] WL[114] WL[113] WL[112] WL[111] WL[110] WL[109] WL[108] WL[107] WL[106] WL[105] WL[104] WL[103] WL[102] WL[101]
+ WL[100] WL[99] WL[98] WL[97] WL[96] WL[95] WL[94] WL[93] WL[92] WL[91] WL[90] WL[89] WL[88] WL[87] WL[86] WL[85] WL[84] WL[83] WL[82]
+ WL[81] WL[80] WL[79] WL[78] WL[77] WL[76] WL[75] WL[74] WL[73] WL[72] WL[71] WL[70] WL[69] WL[68] WL[67] WL[66] WL[65] WL[64] WL[63]
+ WL[62] WL[61] WL[60] WL[59] WL[58] WL[57] WL[56] WL[55] WL[54] WL[53] WL[52] WL[51] WL[50] WL[49] WL[48] WL[47] WL[46] WL[45] WL[44]
+ WL[43] WL[42] WL[41] WL[40] WL[39] WL[38] WL[37] WL[36] WL[35] WL[34] WL[33] WL[32] WL[31] WL[30] WL[29] WL[28] WL[27] WL[26] WL[25]
+ WL[24] WL[23] WL[22] WL[21] WL[20] WL[19] WL[18] WL[17] WL[16] WL[15] WL[14] WL[13] WL[12] WL[11] WL[10] WL[9] WL[8] WL[7] WL[6] WL[5]
+ WL[4] WL[3] WL[2] WL[1] WL[0] DOUT[3] DOUTB[3] VDD VSS bit_slice
XS[2] PRE_B SEL0 SEL0B SEL1 SEL1B SAE WE DL[2] WL[127] WL[126] WL[125] WL[124] WL[123] WL[122] WL[121] WL[120] WL[119] WL[118]
+ WL[117] WL[116] WL[115] WL[114] WL[113] WL[112] WL[111] WL[110] WL[109] WL[108] WL[107] WL[106] WL[105] WL[104] WL[103] WL[102] WL[101]
+ WL[100] WL[99] WL[98] WL[97] WL[96] WL[95] WL[94] WL[93] WL[92] WL[91] WL[90] WL[89] WL[88] WL[87] WL[86] WL[85] WL[84] WL[83] WL[82]
+ WL[81] WL[80] WL[79] WL[78] WL[77] WL[76] WL[75] WL[74] WL[73] WL[72] WL[71] WL[70] WL[69] WL[68] WL[67] WL[66] WL[65] WL[64] WL[63]
+ WL[62] WL[61] WL[60] WL[59] WL[58] WL[57] WL[56] WL[55] WL[54] WL[53] WL[52] WL[51] WL[50] WL[49] WL[48] WL[47] WL[46] WL[45] WL[44]
+ WL[43] WL[42] WL[41] WL[40] WL[39] WL[38] WL[37] WL[36] WL[35] WL[34] WL[33] WL[32] WL[31] WL[30] WL[29] WL[28] WL[27] WL[26] WL[25]
+ WL[24] WL[23] WL[22] WL[21] WL[20] WL[19] WL[18] WL[17] WL[16] WL[15] WL[14] WL[13] WL[12] WL[11] WL[10] WL[9] WL[8] WL[7] WL[6] WL[5]
+ WL[4] WL[3] WL[2] WL[1] WL[0] DOUT[2] DOUTB[2] VDD VSS bit_slice
XS[1] PRE_B SEL0 SEL0B SEL1 SEL1B SAE WE DL[1] WL[127] WL[126] WL[125] WL[124] WL[123] WL[122] WL[121] WL[120] WL[119] WL[118]
+ WL[117] WL[116] WL[115] WL[114] WL[113] WL[112] WL[111] WL[110] WL[109] WL[108] WL[107] WL[106] WL[105] WL[104] WL[103] WL[102] WL[101]
+ WL[100] WL[99] WL[98] WL[97] WL[96] WL[95] WL[94] WL[93] WL[92] WL[91] WL[90] WL[89] WL[88] WL[87] WL[86] WL[85] WL[84] WL[83] WL[82]
+ WL[81] WL[80] WL[79] WL[78] WL[77] WL[76] WL[75] WL[74] WL[73] WL[72] WL[71] WL[70] WL[69] WL[68] WL[67] WL[66] WL[65] WL[64] WL[63]
+ WL[62] WL[61] WL[60] WL[59] WL[58] WL[57] WL[56] WL[55] WL[54] WL[53] WL[52] WL[51] WL[50] WL[49] WL[48] WL[47] WL[46] WL[45] WL[44]
+ WL[43] WL[42] WL[41] WL[40] WL[39] WL[38] WL[37] WL[36] WL[35] WL[34] WL[33] WL[32] WL[31] WL[30] WL[29] WL[28] WL[27] WL[26] WL[25]
+ WL[24] WL[23] WL[22] WL[21] WL[20] WL[19] WL[18] WL[17] WL[16] WL[15] WL[14] WL[13] WL[12] WL[11] WL[10] WL[9] WL[8] WL[7] WL[6] WL[5]
+ WL[4] WL[3] WL[2] WL[1] WL[0] DOUT[1] DOUTB[1] VDD VSS bit_slice
XS[0] PRE_B SEL0 SEL0B SEL1 SEL1B SAE WE DL[0] WL[127] WL[126] WL[125] WL[124] WL[123] WL[122] WL[121] WL[120] WL[119] WL[118]
+ WL[117] WL[116] WL[115] WL[114] WL[113] WL[112] WL[111] WL[110] WL[109] WL[108] WL[107] WL[106] WL[105] WL[104] WL[103] WL[102] WL[101]
+ WL[100] WL[99] WL[98] WL[97] WL[96] WL[95] WL[94] WL[93] WL[92] WL[91] WL[90] WL[89] WL[88] WL[87] WL[86] WL[85] WL[84] WL[83] WL[82]
+ WL[81] WL[80] WL[79] WL[78] WL[77] WL[76] WL[75] WL[74] WL[73] WL[72] WL[71] WL[70] WL[69] WL[68] WL[67] WL[66] WL[65] WL[64] WL[63]
+ WL[62] WL[61] WL[60] WL[59] WL[58] WL[57] WL[56] WL[55] WL[54] WL[53] WL[52] WL[51] WL[50] WL[49] WL[48] WL[47] WL[46] WL[45] WL[44]
+ WL[43] WL[42] WL[41] WL[40] WL[39] WL[38] WL[37] WL[36] WL[35] WL[34] WL[33] WL[32] WL[31] WL[30] WL[29] WL[28] WL[27] WL[26] WL[25]
+ WL[24] WL[23] WL[22] WL[21] WL[20] WL[19] WL[18] WL[17] WL[16] WL[15] WL[14] WL[13] WL[12] WL[11] WL[10] WL[9] WL[8] WL[7] WL[6] WL[5]
+ WL[4] WL[3] WL[2] WL[1] WL[0] DOUT[0] DOUTB[0] VDD VSS bit_slice
XQL SAE DOUT[31] DOUT[30] DOUT[29] DOUT[28] DOUT[27] DOUT[26] DOUT[25] DOUT[24] DOUT[23] DOUT[22] DOUT[21] DOUT[20] DOUT[19]
+ DOUT[18] DOUT[17] DOUT[16] DOUT[15] DOUT[14] DOUT[13] DOUT[12] DOUT[11] DOUT[10] DOUT[9] DOUT[8] DOUT[7] DOUT[6] DOUT[5] DOUT[4] DOUT[3]
+ DOUT[2] DOUT[1] DOUT[0] Q[31] Q[30] Q[29] Q[28] Q[27] Q[26] Q[25] Q[24] Q[23] Q[22] Q[21] Q[20] Q[19] Q[18] Q[17] Q[16] Q[15] Q[14] Q[13]
+ Q[12] Q[11] Q[10] Q[9] Q[8] Q[7] Q[6] Q[5] Q[4] Q[3] Q[2] Q[1] Q[0] VDD VSS out_latch
.ends

* expanding   symbol:  latches/addr_latch.sym # of pins=25
** sym_path: design/latches/addr_latch.sym
** sch_path: design/latches/addr_latch.sch
.subckt addr_latch CLK A[7] A[6] A[5] A[4] A[3] A[2] A[1] A[0] CEN GWEN WEN AL[7] AL[6] AL[5] AL[4] AL[3] AL[2] AL[1] AL[0] CENL
+ GWENL WENL VDD VSS
*.ipin CLK
*.ipin A[7]
*.ipin A[6]
*.ipin A[5]
*.ipin A[4]
*.ipin A[3]
*.ipin A[2]
*.ipin A[1]
*.ipin A[0]
*.ipin CEN
*.ipin GWEN
*.ipin WEN
*.opin AL[7]
*.opin AL[6]
*.opin AL[5]
*.opin AL[4]
*.opin AL[3]
*.opin AL[2]
*.opin AL[1]
*.opin AL[0]
*.opin CENL
*.opin GWENL
*.opin WENL
*.iopin VDD
*.iopin VSS
XCB CLK CLKB VDD VSS inv
XLA[7] A[7] CLKB CLK AL[7] VDD VSS dlatch
XLA[6] A[6] CLKB CLK AL[6] VDD VSS dlatch
XLA[5] A[5] CLKB CLK AL[5] VDD VSS dlatch
XLA[4] A[4] CLKB CLK AL[4] VDD VSS dlatch
XLA[3] A[3] CLKB CLK AL[3] VDD VSS dlatch
XLA[2] A[2] CLKB CLK AL[2] VDD VSS dlatch
XLA[1] A[1] CLKB CLK AL[1] VDD VSS dlatch
XLA[0] A[0] CLKB CLK AL[0] VDD VSS dlatch
XLC CEN CLKB CLK CENL VDD VSS dlatch
XLG GWEN CLKB CLK GWENL VDD VSS dlatch
XLW WEN CLKB CLK WENL VDD VSS dlatch
**** begin user architecture code

* address and control input latches, transparent while CLK is low, hold while CLK is high

**** end user architecture code
.ends

* expanding   symbol:  control/control.sym # of pins=15
** sym_path: design/control/control.sym
** sch_path: design/control/control.sch
.subckt control CLK CENL GWENL WENL A0L PRE_B WLEN SAE WE SEL0 SEL0B SEL1 SEL1B VDD VSS
*.ipin CLK
*.ipin CENL
*.ipin GWENL
*.ipin WENL
*.ipin A0L
*.opin PRE_B
*.opin WLEN
*.opin SAE
*.opin WE
*.opin SEL0
*.opin SEL0B
*.opin SEL1
*.opin SEL1B
*.iopin VDD
*.iopin VSS
XCB CLK CLKB VDD VSS inv
XACT CLKB CENL ACT VDD VSS nor2
XD1 ACT D1 VDD VSS inv
XD2 D1 D2 VDD VSS inv
XD3 D2 D3 VDD VSS inv
XD4 D3 D4 VDD VSS inv
XWN ACT D4 WLENB VDD VSS nand2
XWO WLENB WLEN VDD VSS inv_x4
XP1 ACT PREB1 VDD VSS inv
XP2 PREB1 PRE_B VDD VSS inv
XE1 WLEN E1 VDD VSS inv
XE2 E1 E2 VDD VSS inv
XE3 E2 E3 VDD VSS inv
XE4 E3 E4 VDD VSS inv
XWR GWENL WENL WRITE VDD VSS nor2
XWRB WRITE WRITEB VDD VSS inv
XSN WLEN E4 WRITEB SAEN VDD VSS nand3
XSO SAEN SAE VDD VSS inv_x4
XWEN WLEN WRITE WEB VDD VSS nand2
XWEO WEB WE VDD VSS inv_x4
XS1 A0L NA VDD VSS inv
XS2 NA PA VDD VSS inv
XS3 PA SEL0 VDD VSS inv_x4
XS4 SEL0 SEL0B VDD VSS inv_x4
XS5 NA SEL1 VDD VSS inv_x4
XS6 SEL1 SEL1B VDD VSS inv_x4
**** begin user architecture code

* timing: ACT = CLK & ~CENL; PRE_B follows ACT; WLEN = ACT & delayed ACT; SAE = WLEN & delayed WLEN & read; WE = WLEN & write; SEL* from A0L

**** end user architecture code
.ends

* expanding   symbol:  decoder/row_decoder.sym # of pins=138
** sym_path: design/decoder/row_decoder.sym
** sch_path: design/decoder/row_decoder.sch
.subckt row_decoder A[6] A[5] A[4] A[3] A[2] A[1] A[0] WLEN WL[127] WL[126] WL[125] WL[124] WL[123] WL[122] WL[121] WL[120]
+ WL[119] WL[118] WL[117] WL[116] WL[115] WL[114] WL[113] WL[112] WL[111] WL[110] WL[109] WL[108] WL[107] WL[106] WL[105] WL[104] WL[103]
+ WL[102] WL[101] WL[100] WL[99] WL[98] WL[97] WL[96] WL[95] WL[94] WL[93] WL[92] WL[91] WL[90] WL[89] WL[88] WL[87] WL[86] WL[85] WL[84]
+ WL[83] WL[82] WL[81] WL[80] WL[79] WL[78] WL[77] WL[76] WL[75] WL[74] WL[73] WL[72] WL[71] WL[70] WL[69] WL[68] WL[67] WL[66] WL[65]
+ WL[64] WL[63] WL[62] WL[61] WL[60] WL[59] WL[58] WL[57] WL[56] WL[55] WL[54] WL[53] WL[52] WL[51] WL[50] WL[49] WL[48] WL[47] WL[46]
+ WL[45] WL[44] WL[43] WL[42] WL[41] WL[40] WL[39] WL[38] WL[37] WL[36] WL[35] WL[34] WL[33] WL[32] WL[31] WL[30] WL[29] WL[28] WL[27]
+ WL[26] WL[25] WL[24] WL[23] WL[22] WL[21] WL[20] WL[19] WL[18] WL[17] WL[16] WL[15] WL[14] WL[13] WL[12] WL[11] WL[10] WL[9] WL[8] WL[7]
+ WL[6] WL[5] WL[4] WL[3] WL[2] WL[1] WL[0] VDD VSS
*.ipin A[6]
*.ipin A[5]
*.ipin A[4]
*.ipin A[3]
*.ipin A[2]
*.ipin A[1]
*.ipin A[0]
*.ipin WLEN
*.opin WL[127]
*.opin WL[126]
*.opin WL[125]
*.opin WL[124]
*.opin WL[123]
*.opin WL[122]
*.opin WL[121]
*.opin WL[120]
*.opin WL[119]
*.opin WL[118]
*.opin WL[117]
*.opin WL[116]
*.opin WL[115]
*.opin WL[114]
*.opin WL[113]
*.opin WL[112]
*.opin WL[111]
*.opin WL[110]
*.opin WL[109]
*.opin WL[108]
*.opin WL[107]
*.opin WL[106]
*.opin WL[105]
*.opin WL[104]
*.opin WL[103]
*.opin WL[102]
*.opin WL[101]
*.opin WL[100]
*.opin WL[99]
*.opin WL[98]
*.opin WL[97]
*.opin WL[96]
*.opin WL[95]
*.opin WL[94]
*.opin WL[93]
*.opin WL[92]
*.opin WL[91]
*.opin WL[90]
*.opin WL[89]
*.opin WL[88]
*.opin WL[87]
*.opin WL[86]
*.opin WL[85]
*.opin WL[84]
*.opin WL[83]
*.opin WL[82]
*.opin WL[81]
*.opin WL[80]
*.opin WL[79]
*.opin WL[78]
*.opin WL[77]
*.opin WL[76]
*.opin WL[75]
*.opin WL[74]
*.opin WL[73]
*.opin WL[72]
*.opin WL[71]
*.opin WL[70]
*.opin WL[69]
*.opin WL[68]
*.opin WL[67]
*.opin WL[66]
*.opin WL[65]
*.opin WL[64]
*.opin WL[63]
*.opin WL[62]
*.opin WL[61]
*.opin WL[60]
*.opin WL[59]
*.opin WL[58]
*.opin WL[57]
*.opin WL[56]
*.opin WL[55]
*.opin WL[54]
*.opin WL[53]
*.opin WL[52]
*.opin WL[51]
*.opin WL[50]
*.opin WL[49]
*.opin WL[48]
*.opin WL[47]
*.opin WL[46]
*.opin WL[45]
*.opin WL[44]
*.opin WL[43]
*.opin WL[42]
*.opin WL[41]
*.opin WL[40]
*.opin WL[39]
*.opin WL[38]
*.opin WL[37]
*.opin WL[36]
*.opin WL[35]
*.opin WL[34]
*.opin WL[33]
*.opin WL[32]
*.opin WL[31]
*.opin WL[30]
*.opin WL[29]
*.opin WL[28]
*.opin WL[27]
*.opin WL[26]
*.opin WL[25]
*.opin WL[24]
*.opin WL[23]
*.opin WL[22]
*.opin WL[21]
*.opin WL[20]
*.opin WL[19]
*.opin WL[18]
*.opin WL[17]
*.opin WL[16]
*.opin WL[15]
*.opin WL[14]
*.opin WL[13]
*.opin WL[12]
*.opin WL[11]
*.opin WL[10]
*.opin WL[9]
*.opin WL[8]
*.opin WL[7]
*.opin WL[6]
*.opin WL[5]
*.opin WL[4]
*.opin WL[3]
*.opin WL[2]
*.opin WL[1]
*.opin WL[0]
*.iopin VDD
*.iopin VSS
XP3 A[2] A[1] A[0] X[7] X[6] X[5] X[4] X[3] X[2] X[1] X[0] VDD VSS predec3
XP4 A[6] A[5] A[4] A[3] Y[15] Y[14] Y[13] Y[12] Y[11] Y[10] Y[9] Y[8] Y[7] Y[6] Y[5] Y[4] Y[3] Y[2] Y[1] Y[0] VDD VSS predec4
XWD X[7] X[6] X[5] X[4] X[3] X[2] X[1] X[0] Y[15] Y[14] Y[13] Y[12] Y[11] Y[10] Y[9] Y[8] Y[7] Y[6] Y[5] Y[4] Y[3] Y[2] Y[1] Y[0]
+ WLEN WL[127] WL[126] WL[125] WL[124] WL[123] WL[122] WL[121] WL[120] WL[119] WL[118] WL[117] WL[116] WL[115] WL[114] WL[113] WL[112]
+ WL[111] WL[110] WL[109] WL[108] WL[107] WL[106] WL[105] WL[104] WL[103] WL[102] WL[101] WL[100] WL[99] WL[98] WL[97] WL[96] WL[95] WL[94]
+ WL[93] WL[92] WL[91] WL[90] WL[89] WL[88] WL[87] WL[86] WL[85] WL[84] WL[83] WL[82] WL[81] WL[80] WL[79] WL[78] WL[77] WL[76] WL[75]
+ WL[74] WL[73] WL[72] WL[71] WL[70] WL[69] WL[68] WL[67] WL[66] WL[65] WL[64] WL[63] WL[62] WL[61] WL[60] WL[59] WL[58] WL[57] WL[56]
+ WL[55] WL[54] WL[53] WL[52] WL[51] WL[50] WL[49] WL[48] WL[47] WL[46] WL[45] WL[44] WL[43] WL[42] WL[41] WL[40] WL[39] WL[38] WL[37]
+ WL[36] WL[35] WL[34] WL[33] WL[32] WL[31] WL[30] WL[29] WL[28] WL[27] WL[26] WL[25] WL[24] WL[23] WL[22] WL[21] WL[20] WL[19] WL[18]
+ WL[17] WL[16] WL[15] WL[14] WL[13] WL[12] WL[11] WL[10] WL[9] WL[8] WL[7] WL[6] WL[5] WL[4] WL[3] WL[2] WL[1] WL[0] VDD VSS wl_drivers
**** begin user architecture code

* 7-bit row decoder: A[2:0] -> X (8), A[6:3] -> Y (16), WL[8*j+k] = X[k] & Y[j] & WLEN

**** end user architecture code
.ends

* expanding   symbol:  latches/data_latch.sym # of pins=67
** sym_path: design/latches/data_latch.sym
** sch_path: design/latches/data_latch.sch
.subckt data_latch CLK D[31] D[30] D[29] D[28] D[27] D[26] D[25] D[24] D[23] D[22] D[21] D[20] D[19] D[18] D[17] D[16] D[15] D[14]
+ D[13] D[12] D[11] D[10] D[9] D[8] D[7] D[6] D[5] D[4] D[3] D[2] D[1] D[0] Q[31] Q[30] Q[29] Q[28] Q[27] Q[26] Q[25] Q[24] Q[23] Q[22]
+ Q[21] Q[20] Q[19] Q[18] Q[17] Q[16] Q[15] Q[14] Q[13] Q[12] Q[11] Q[10] Q[9] Q[8] Q[7] Q[6] Q[5] Q[4] Q[3] Q[2] Q[1] Q[0] VDD VSS
*.ipin CLK
*.ipin D[31]
*.ipin D[30]
*.ipin D[29]
*.ipin D[28]
*.ipin D[27]
*.ipin D[26]
*.ipin D[25]
*.ipin D[24]
*.ipin D[23]
*.ipin D[22]
*.ipin D[21]
*.ipin D[20]
*.ipin D[19]
*.ipin D[18]
*.ipin D[17]
*.ipin D[16]
*.ipin D[15]
*.ipin D[14]
*.ipin D[13]
*.ipin D[12]
*.ipin D[11]
*.ipin D[10]
*.ipin D[9]
*.ipin D[8]
*.ipin D[7]
*.ipin D[6]
*.ipin D[5]
*.ipin D[4]
*.ipin D[3]
*.ipin D[2]
*.ipin D[1]
*.ipin D[0]
*.opin Q[31]
*.opin Q[30]
*.opin Q[29]
*.opin Q[28]
*.opin Q[27]
*.opin Q[26]
*.opin Q[25]
*.opin Q[24]
*.opin Q[23]
*.opin Q[22]
*.opin Q[21]
*.opin Q[20]
*.opin Q[19]
*.opin Q[18]
*.opin Q[17]
*.opin Q[16]
*.opin Q[15]
*.opin Q[14]
*.opin Q[13]
*.opin Q[12]
*.opin Q[11]
*.opin Q[10]
*.opin Q[9]
*.opin Q[8]
*.opin Q[7]
*.opin Q[6]
*.opin Q[5]
*.opin Q[4]
*.opin Q[3]
*.opin Q[2]
*.opin Q[1]
*.opin Q[0]
*.iopin VDD
*.iopin VSS
XCB CLK CLKB VDD VSS inv
XL[31] D[31] CLKB CLK Q[31] VDD VSS dlatch
XL[30] D[30] CLKB CLK Q[30] VDD VSS dlatch
XL[29] D[29] CLKB CLK Q[29] VDD VSS dlatch
XL[28] D[28] CLKB CLK Q[28] VDD VSS dlatch
XL[27] D[27] CLKB CLK Q[27] VDD VSS dlatch
XL[26] D[26] CLKB CLK Q[26] VDD VSS dlatch
XL[25] D[25] CLKB CLK Q[25] VDD VSS dlatch
XL[24] D[24] CLKB CLK Q[24] VDD VSS dlatch
XL[23] D[23] CLKB CLK Q[23] VDD VSS dlatch
XL[22] D[22] CLKB CLK Q[22] VDD VSS dlatch
XL[21] D[21] CLKB CLK Q[21] VDD VSS dlatch
XL[20] D[20] CLKB CLK Q[20] VDD VSS dlatch
XL[19] D[19] CLKB CLK Q[19] VDD VSS dlatch
XL[18] D[18] CLKB CLK Q[18] VDD VSS dlatch
XL[17] D[17] CLKB CLK Q[17] VDD VSS dlatch
XL[16] D[16] CLKB CLK Q[16] VDD VSS dlatch
XL[15] D[15] CLKB CLK Q[15] VDD VSS dlatch
XL[14] D[14] CLKB CLK Q[14] VDD VSS dlatch
XL[13] D[13] CLKB CLK Q[13] VDD VSS dlatch
XL[12] D[12] CLKB CLK Q[12] VDD VSS dlatch
XL[11] D[11] CLKB CLK Q[11] VDD VSS dlatch
XL[10] D[10] CLKB CLK Q[10] VDD VSS dlatch
XL[9] D[9] CLKB CLK Q[9] VDD VSS dlatch
XL[8] D[8] CLKB CLK Q[8] VDD VSS dlatch
XL[7] D[7] CLKB CLK Q[7] VDD VSS dlatch
XL[6] D[6] CLKB CLK Q[6] VDD VSS dlatch
XL[5] D[5] CLKB CLK Q[5] VDD VSS dlatch
XL[4] D[4] CLKB CLK Q[4] VDD VSS dlatch
XL[3] D[3] CLKB CLK Q[3] VDD VSS dlatch
XL[2] D[2] CLKB CLK Q[2] VDD VSS dlatch
XL[1] D[1] CLKB CLK Q[1] VDD VSS dlatch
XL[0] D[0] CLKB CLK Q[0] VDD VSS dlatch
**** begin user architecture code

* write-data input latch, transparent while CLK is low, holds while CLK is high

**** end user architecture code
.ends

* expanding   symbol:  macro/bit_slice.sym # of pins=140
** sym_path: design/macro/bit_slice.sym
** sch_path: design/macro/bit_slice.sch
.subckt bit_slice PRE_B SEL0 SEL0B SEL1 SEL1B SAE WE DIN WL[127] WL[126] WL[125] WL[124] WL[123] WL[122] WL[121] WL[120] WL[119]
+ WL[118] WL[117] WL[116] WL[115] WL[114] WL[113] WL[112] WL[111] WL[110] WL[109] WL[108] WL[107] WL[106] WL[105] WL[104] WL[103] WL[102]
+ WL[101] WL[100] WL[99] WL[98] WL[97] WL[96] WL[95] WL[94] WL[93] WL[92] WL[91] WL[90] WL[89] WL[88] WL[87] WL[86] WL[85] WL[84] WL[83]
+ WL[82] WL[81] WL[80] WL[79] WL[78] WL[77] WL[76] WL[75] WL[74] WL[73] WL[72] WL[71] WL[70] WL[69] WL[68] WL[67] WL[66] WL[65] WL[64]
+ WL[63] WL[62] WL[61] WL[60] WL[59] WL[58] WL[57] WL[56] WL[55] WL[54] WL[53] WL[52] WL[51] WL[50] WL[49] WL[48] WL[47] WL[46] WL[45]
+ WL[44] WL[43] WL[42] WL[41] WL[40] WL[39] WL[38] WL[37] WL[36] WL[35] WL[34] WL[33] WL[32] WL[31] WL[30] WL[29] WL[28] WL[27] WL[26]
+ WL[25] WL[24] WL[23] WL[22] WL[21] WL[20] WL[19] WL[18] WL[17] WL[16] WL[15] WL[14] WL[13] WL[12] WL[11] WL[10] WL[9] WL[8] WL[7] WL[6]
+ WL[5] WL[4] WL[3] WL[2] WL[1] WL[0] DOUT DOUTB VDD VSS
*.ipin PRE_B
*.ipin SEL0
*.ipin SEL0B
*.ipin SEL1
*.ipin SEL1B
*.ipin SAE
*.ipin WE
*.ipin DIN
*.ipin WL[127]
*.ipin WL[126]
*.ipin WL[125]
*.ipin WL[124]
*.ipin WL[123]
*.ipin WL[122]
*.ipin WL[121]
*.ipin WL[120]
*.ipin WL[119]
*.ipin WL[118]
*.ipin WL[117]
*.ipin WL[116]
*.ipin WL[115]
*.ipin WL[114]
*.ipin WL[113]
*.ipin WL[112]
*.ipin WL[111]
*.ipin WL[110]
*.ipin WL[109]
*.ipin WL[108]
*.ipin WL[107]
*.ipin WL[106]
*.ipin WL[105]
*.ipin WL[104]
*.ipin WL[103]
*.ipin WL[102]
*.ipin WL[101]
*.ipin WL[100]
*.ipin WL[99]
*.ipin WL[98]
*.ipin WL[97]
*.ipin WL[96]
*.ipin WL[95]
*.ipin WL[94]
*.ipin WL[93]
*.ipin WL[92]
*.ipin WL[91]
*.ipin WL[90]
*.ipin WL[89]
*.ipin WL[88]
*.ipin WL[87]
*.ipin WL[86]
*.ipin WL[85]
*.ipin WL[84]
*.ipin WL[83]
*.ipin WL[82]
*.ipin WL[81]
*.ipin WL[80]
*.ipin WL[79]
*.ipin WL[78]
*.ipin WL[77]
*.ipin WL[76]
*.ipin WL[75]
*.ipin WL[74]
*.ipin WL[73]
*.ipin WL[72]
*.ipin WL[71]
*.ipin WL[70]
*.ipin WL[69]
*.ipin WL[68]
*.ipin WL[67]
*.ipin WL[66]
*.ipin WL[65]
*.ipin WL[64]
*.ipin WL[63]
*.ipin WL[62]
*.ipin WL[61]
*.ipin WL[60]
*.ipin WL[59]
*.ipin WL[58]
*.ipin WL[57]
*.ipin WL[56]
*.ipin WL[55]
*.ipin WL[54]
*.ipin WL[53]
*.ipin WL[52]
*.ipin WL[51]
*.ipin WL[50]
*.ipin WL[49]
*.ipin WL[48]
*.ipin WL[47]
*.ipin WL[46]
*.ipin WL[45]
*.ipin WL[44]
*.ipin WL[43]
*.ipin WL[42]
*.ipin WL[41]
*.ipin WL[40]
*.ipin WL[39]
*.ipin WL[38]
*.ipin WL[37]
*.ipin WL[36]
*.ipin WL[35]
*.ipin WL[34]
*.ipin WL[33]
*.ipin WL[32]
*.ipin WL[31]
*.ipin WL[30]
*.ipin WL[29]
*.ipin WL[28]
*.ipin WL[27]
*.ipin WL[26]
*.ipin WL[25]
*.ipin WL[24]
*.ipin WL[23]
*.ipin WL[22]
*.ipin WL[21]
*.ipin WL[20]
*.ipin WL[19]
*.ipin WL[18]
*.ipin WL[17]
*.ipin WL[16]
*.ipin WL[15]
*.ipin WL[14]
*.ipin WL[13]
*.ipin WL[12]
*.ipin WL[11]
*.ipin WL[10]
*.ipin WL[9]
*.ipin WL[8]
*.ipin WL[7]
*.ipin WL[6]
*.ipin WL[5]
*.ipin WL[4]
*.ipin WL[3]
*.ipin WL[2]
*.ipin WL[1]
*.ipin WL[0]
*.iopin DOUT
*.iopin DOUTB
*.iopin VDD
*.iopin VSS
XA0 WL[127] WL[126] WL[125] WL[124] WL[123] WL[122] WL[121] WL[120] WL[119] WL[118] WL[117] WL[116] WL[115] WL[114] WL[113]
+ WL[112] WL[111] WL[110] WL[109] WL[108] WL[107] WL[106] WL[105] WL[104] WL[103] WL[102] WL[101] WL[100] WL[99] WL[98] WL[97] WL[96]
+ WL[95] WL[94] WL[93] WL[92] WL[91] WL[90] WL[89] WL[88] WL[87] WL[86] WL[85] WL[84] WL[83] WL[82] WL[81] WL[80] WL[79] WL[78] WL[77]
+ WL[76] WL[75] WL[74] WL[73] WL[72] WL[71] WL[70] WL[69] WL[68] WL[67] WL[66] WL[65] WL[64] WL[63] WL[62] WL[61] WL[60] WL[59] WL[58]
+ WL[57] WL[56] WL[55] WL[54] WL[53] WL[52] WL[51] WL[50] WL[49] WL[48] WL[47] WL[46] WL[45] WL[44] WL[43] WL[42] WL[41] WL[40] WL[39]
+ WL[38] WL[37] WL[36] WL[35] WL[34] WL[33] WL[32] WL[31] WL[30] WL[29] WL[28] WL[27] WL[26] WL[25] WL[24] WL[23] WL[22] WL[21] WL[20]
+ WL[19] WL[18] WL[17] WL[16] WL[15] WL[14] WL[13] WL[12] WL[11] WL[10] WL[9] WL[8] WL[7] WL[6] WL[5] WL[4] WL[3] WL[2] WL[1] WL[0] BL0
+ BLB0 VDD VSS bl_pair
XA1 WL[127] WL[126] WL[125] WL[124] WL[123] WL[122] WL[121] WL[120] WL[119] WL[118] WL[117] WL[116] WL[115] WL[114] WL[113]
+ WL[112] WL[111] WL[110] WL[109] WL[108] WL[107] WL[106] WL[105] WL[104] WL[103] WL[102] WL[101] WL[100] WL[99] WL[98] WL[97] WL[96]
+ WL[95] WL[94] WL[93] WL[92] WL[91] WL[90] WL[89] WL[88] WL[87] WL[86] WL[85] WL[84] WL[83] WL[82] WL[81] WL[80] WL[79] WL[78] WL[77]
+ WL[76] WL[75] WL[74] WL[73] WL[72] WL[71] WL[70] WL[69] WL[68] WL[67] WL[66] WL[65] WL[64] WL[63] WL[62] WL[61] WL[60] WL[59] WL[58]
+ WL[57] WL[56] WL[55] WL[54] WL[53] WL[52] WL[51] WL[50] WL[49] WL[48] WL[47] WL[46] WL[45] WL[44] WL[43] WL[42] WL[41] WL[40] WL[39]
+ WL[38] WL[37] WL[36] WL[35] WL[34] WL[33] WL[32] WL[31] WL[30] WL[29] WL[28] WL[27] WL[26] WL[25] WL[24] WL[23] WL[22] WL[21] WL[20]
+ WL[19] WL[18] WL[17] WL[16] WL[15] WL[14] WL[13] WL[12] WL[11] WL[10] WL[9] WL[8] WL[7] WL[6] WL[5] WL[4] WL[3] WL[2] WL[1] WL[0] BL1
+ BLB1 VDD VSS bl_pair
XPC0 PRE_B BL0 BLB0 VDD VSS precharge
XPC1 PRE_B BL1 BLB1 VDD VSS precharge
XMX SEL0 SEL0B SEL1 SEL1B BL0 BLB0 BL1 BLB1 BLM BLBM VDD VSS column_mux
XSA SAE BLM BLBM DOUT DOUTB VDD VSS sense_amp
XWR WE DIN BLM BLBM VDD VSS write_driver
**** begin user architecture code

* one I/O bit: two bit-line pairs (mux 2), precharge on each, column mux, sense amp, write driver; both precharges share PRE_B

**** end user architecture code
.ends

* expanding   symbol:  latches/out_latch.sym # of pins=67
** sym_path: design/latches/out_latch.sym
** sch_path: design/latches/out_latch.sch
.subckt out_latch SAE D[31] D[30] D[29] D[28] D[27] D[26] D[25] D[24] D[23] D[22] D[21] D[20] D[19] D[18] D[17] D[16] D[15] D[14]
+ D[13] D[12] D[11] D[10] D[9] D[8] D[7] D[6] D[5] D[4] D[3] D[2] D[1] D[0] Q[31] Q[30] Q[29] Q[28] Q[27] Q[26] Q[25] Q[24] Q[23] Q[22]
+ Q[21] Q[20] Q[19] Q[18] Q[17] Q[16] Q[15] Q[14] Q[13] Q[12] Q[11] Q[10] Q[9] Q[8] Q[7] Q[6] Q[5] Q[4] Q[3] Q[2] Q[1] Q[0] VDD VSS
*.ipin SAE
*.ipin D[31]
*.ipin D[30]
*.ipin D[29]
*.ipin D[28]
*.ipin D[27]
*.ipin D[26]
*.ipin D[25]
*.ipin D[24]
*.ipin D[23]
*.ipin D[22]
*.ipin D[21]
*.ipin D[20]
*.ipin D[19]
*.ipin D[18]
*.ipin D[17]
*.ipin D[16]
*.ipin D[15]
*.ipin D[14]
*.ipin D[13]
*.ipin D[12]
*.ipin D[11]
*.ipin D[10]
*.ipin D[9]
*.ipin D[8]
*.ipin D[7]
*.ipin D[6]
*.ipin D[5]
*.ipin D[4]
*.ipin D[3]
*.ipin D[2]
*.ipin D[1]
*.ipin D[0]
*.opin Q[31]
*.opin Q[30]
*.opin Q[29]
*.opin Q[28]
*.opin Q[27]
*.opin Q[26]
*.opin Q[25]
*.opin Q[24]
*.opin Q[23]
*.opin Q[22]
*.opin Q[21]
*.opin Q[20]
*.opin Q[19]
*.opin Q[18]
*.opin Q[17]
*.opin Q[16]
*.opin Q[15]
*.opin Q[14]
*.opin Q[13]
*.opin Q[12]
*.opin Q[11]
*.opin Q[10]
*.opin Q[9]
*.opin Q[8]
*.opin Q[7]
*.opin Q[6]
*.opin Q[5]
*.opin Q[4]
*.opin Q[3]
*.opin Q[2]
*.opin Q[1]
*.opin Q[0]
*.iopin VDD
*.iopin VSS
XEB SAE SAEB VDD VSS inv
XL[31] D[31] SAE SAEB Q[31] VDD VSS dlatch
XL[30] D[30] SAE SAEB Q[30] VDD VSS dlatch
XL[29] D[29] SAE SAEB Q[29] VDD VSS dlatch
XL[28] D[28] SAE SAEB Q[28] VDD VSS dlatch
XL[27] D[27] SAE SAEB Q[27] VDD VSS dlatch
XL[26] D[26] SAE SAEB Q[26] VDD VSS dlatch
XL[25] D[25] SAE SAEB Q[25] VDD VSS dlatch
XL[24] D[24] SAE SAEB Q[24] VDD VSS dlatch
XL[23] D[23] SAE SAEB Q[23] VDD VSS dlatch
XL[22] D[22] SAE SAEB Q[22] VDD VSS dlatch
XL[21] D[21] SAE SAEB Q[21] VDD VSS dlatch
XL[20] D[20] SAE SAEB Q[20] VDD VSS dlatch
XL[19] D[19] SAE SAEB Q[19] VDD VSS dlatch
XL[18] D[18] SAE SAEB Q[18] VDD VSS dlatch
XL[17] D[17] SAE SAEB Q[17] VDD VSS dlatch
XL[16] D[16] SAE SAEB Q[16] VDD VSS dlatch
XL[15] D[15] SAE SAEB Q[15] VDD VSS dlatch
XL[14] D[14] SAE SAEB Q[14] VDD VSS dlatch
XL[13] D[13] SAE SAEB Q[13] VDD VSS dlatch
XL[12] D[12] SAE SAEB Q[12] VDD VSS dlatch
XL[11] D[11] SAE SAEB Q[11] VDD VSS dlatch
XL[10] D[10] SAE SAEB Q[10] VDD VSS dlatch
XL[9] D[9] SAE SAEB Q[9] VDD VSS dlatch
XL[8] D[8] SAE SAEB Q[8] VDD VSS dlatch
XL[7] D[7] SAE SAEB Q[7] VDD VSS dlatch
XL[6] D[6] SAE SAEB Q[6] VDD VSS dlatch
XL[5] D[5] SAE SAEB Q[5] VDD VSS dlatch
XL[4] D[4] SAE SAEB Q[4] VDD VSS dlatch
XL[3] D[3] SAE SAEB Q[3] VDD VSS dlatch
XL[2] D[2] SAE SAEB Q[2] VDD VSS dlatch
XL[1] D[1] SAE SAEB Q[1] VDD VSS dlatch
XL[0] D[0] SAE SAEB Q[0] VDD VSS dlatch
**** begin user architecture code

* read-data output latch, transparent while SAE is high, holds the resolved value after SAE falls

**** end user architecture code
.ends

* expanding   symbol:  gates/inv.sym # of pins=4
** sym_path: design/gates/inv.sym
** sch_path: design/gates/inv.sch
.subckt inv A Y VDD VSS
*.ipin A
*.opin Y
*.iopin VDD
*.iopin VSS
XMP Y A VDD VDD sg13_lv_pmos w=1.0u l=0.13u ng=1 m=1
XMN Y A VSS VSS sg13_lv_nmos w=0.5u l=0.13u ng=1 m=1
**** begin user architecture code

* inverter, N 0.5 um / P 1.0 um

**** end user architecture code
.ends

* expanding   symbol:  latches/dlatch.sym # of pins=6
** sym_path: design/latches/dlatch.sym
** sch_path: design/latches/dlatch.sch
.subckt dlatch D EN ENB Q VDD VSS
*.ipin D
*.ipin EN
*.ipin ENB
*.opin Q
*.iopin VDD
*.iopin VSS
XMNI N1 EN D VSS sg13_lv_nmos w=1.0u l=0.13u ng=1 m=1
XMPI N1 ENB D VDD sg13_lv_pmos w=1.0u l=0.13u ng=1 m=1
XMP1 QB N1 VDD VDD sg13_lv_pmos w=1.0u l=0.13u ng=1 m=1
XMN1 QB N1 VSS VSS sg13_lv_nmos w=0.5u l=0.13u ng=1 m=1
XMP2 Q QB VDD VDD sg13_lv_pmos w=1.0u l=0.13u ng=1 m=1
XMN2 Q QB VSS VSS sg13_lv_nmos w=0.5u l=0.13u ng=1 m=1
XMNF N1 ENB Q VSS sg13_lv_nmos w=0.3u l=0.13u ng=1 m=1
XMPF N1 EN Q VDD sg13_lv_pmos w=0.3u l=0.13u ng=1 m=1
**** begin user architecture code

* D latch: transparent while EN=1 (ENB=0); a weak feedback gate holds N1 when closed

**** end user architecture code
.ends

* expanding   symbol:  gates/nor2.sym # of pins=5
** sym_path: design/gates/nor2.sym
** sch_path: design/gates/nor2.sch
.subckt nor2 A B Y VDD VSS
*.ipin A
*.ipin B
*.opin Y
*.iopin VDD
*.iopin VSS
XMP0 N1 A VDD VDD sg13_lv_pmos w=2.0u l=0.13u ng=1 m=1
XMP1 Y B N1 VDD sg13_lv_pmos w=2.0u l=0.13u ng=1 m=1
XMN0 Y A VSS VSS sg13_lv_nmos w=0.5u l=0.13u ng=1 m=1
XMN1 Y B VSS VSS sg13_lv_nmos w=0.5u l=0.13u ng=1 m=1
**** begin user architecture code

* 2-input NOR, N 0.5 um / P 2.0 um stack

**** end user architecture code
.ends

* expanding   symbol:  gates/nand2.sym # of pins=5
** sym_path: design/gates/nand2.sym
** sch_path: design/gates/nand2.sch
.subckt nand2 A B Y VDD VSS
*.ipin A
*.ipin B
*.opin Y
*.iopin VDD
*.iopin VSS
XMP0 Y A VDD VDD sg13_lv_pmos w=1.0u l=0.13u ng=1 m=1
XMP1 Y B VDD VDD sg13_lv_pmos w=1.0u l=0.13u ng=1 m=1
XMN0 Y A N1 VSS sg13_lv_nmos w=1.0u l=0.13u ng=1 m=1
XMN1 N1 B VSS VSS sg13_lv_nmos w=1.0u l=0.13u ng=1 m=1
**** begin user architecture code

* 2-input NAND, N 1.0 um stack / P 1.0 um

**** end user architecture code
.ends

* expanding   symbol:  gates/inv_x4.sym # of pins=4
** sym_path: design/gates/inv_x4.sym
** sch_path: design/gates/inv_x4.sch
.subckt inv_x4 A Y VDD VSS
*.ipin A
*.opin Y
*.iopin VDD
*.iopin VSS
XMP Y A VDD VDD sg13_lv_pmos w=4.0u l=0.13u ng=1 m=1
XMN Y A VSS VSS sg13_lv_nmos w=2.0u l=0.13u ng=1 m=1
**** begin user architecture code

* inverter, 4x drive: N 2.0 um / P 4.0 um

**** end user architecture code
.ends

* expanding   symbol:  gates/nand3.sym # of pins=6
** sym_path: design/gates/nand3.sym
** sch_path: design/gates/nand3.sch
.subckt nand3 A B C Y VDD VSS
*.ipin A
*.ipin B
*.ipin C
*.opin Y
*.iopin VDD
*.iopin VSS
XMP0 Y A VDD VDD sg13_lv_pmos w=1.0u l=0.13u ng=1 m=1
XMP1 Y B VDD VDD sg13_lv_pmos w=1.0u l=0.13u ng=1 m=1
XMP2 Y C VDD VDD sg13_lv_pmos w=1.0u l=0.13u ng=1 m=1
XMN0 Y A N1 VSS sg13_lv_nmos w=1.5u l=0.13u ng=1 m=1
XMN1 N1 B N2 VSS sg13_lv_nmos w=1.5u l=0.13u ng=1 m=1
XMN2 N2 C VSS VSS sg13_lv_nmos w=1.5u l=0.13u ng=1 m=1
**** begin user architecture code

* 3-input NAND, N 1.5 um stack / P 1.0 um

**** end user architecture code
.ends

* expanding   symbol:  decoder/predec3.sym # of pins=13
** sym_path: design/decoder/predec3.sym
** sch_path: design/decoder/predec3.sch
.subckt predec3 A[2] A[1] A[0] X[7] X[6] X[5] X[4] X[3] X[2] X[1] X[0] VDD VSS
*.ipin A[2]
*.ipin A[1]
*.ipin A[0]
*.opin X[7]
*.opin X[6]
*.opin X[5]
*.opin X[4]
*.opin X[3]
*.opin X[2]
*.opin X[1]
*.opin X[0]
*.iopin VDD
*.iopin VSS
XI0 A[0] A0B VDD VSS inv
XI1 A[1] A1B VDD VSS inv
XI2 A[2] A2B VDD VSS inv
XN0 A0B A1B A2B N0 VDD VSS nand3
XO0 N0 X[0] VDD VSS inv
XN1 A[0] A1B A2B N1 VDD VSS nand3
XO1 N1 X[1] VDD VSS inv
XN2 A0B A[1] A2B N2 VDD VSS nand3
XO2 N2 X[2] VDD VSS inv
XN3 A[0] A[1] A2B N3 VDD VSS nand3
XO3 N3 X[3] VDD VSS inv
XN4 A0B A1B A[2] N4 VDD VSS nand3
XO4 N4 X[4] VDD VSS inv
XN5 A[0] A1B A[2] N5 VDD VSS nand3
XO5 N5 X[5] VDD VSS inv
XN6 A0B A[1] A[2] N6 VDD VSS nand3
XO6 N6 X[6] VDD VSS inv
XN7 A[0] A[1] A[2] N7 VDD VSS nand3
XO7 N7 X[7] VDD VSS inv
**** begin user architecture code

* 3-to-8 predecoder, active-high one-hot X[k], k = A[2:0]

**** end user architecture code
.ends

* expanding   symbol:  decoder/predec4.sym # of pins=22
** sym_path: design/decoder/predec4.sym
** sch_path: design/decoder/predec4.sch
.subckt predec4 A[3] A[2] A[1] A[0] Y[15] Y[14] Y[13] Y[12] Y[11] Y[10] Y[9] Y[8] Y[7] Y[6] Y[5] Y[4] Y[3] Y[2] Y[1] Y[0] VDD VSS
*.ipin A[3]
*.ipin A[2]
*.ipin A[1]
*.ipin A[0]
*.opin Y[15]
*.opin Y[14]
*.opin Y[13]
*.opin Y[12]
*.opin Y[11]
*.opin Y[10]
*.opin Y[9]
*.opin Y[8]
*.opin Y[7]
*.opin Y[6]
*.opin Y[5]
*.opin Y[4]
*.opin Y[3]
*.opin Y[2]
*.opin Y[1]
*.opin Y[0]
*.iopin VDD
*.iopin VSS
XI0 A[0] A0B VDD VSS inv
XI1 A[1] A1B VDD VSS inv
XI2 A[2] A2B VDD VSS inv
XI3 A[3] A3B VDD VSS inv
XN0 A0B A1B A2B A3B N0 VDD VSS nand4
XO0 N0 Y[0] VDD VSS inv
XN1 A[0] A1B A2B A3B N1 VDD VSS nand4
XO1 N1 Y[1] VDD VSS inv
XN2 A0B A[1] A2B A3B N2 VDD VSS nand4
XO2 N2 Y[2] VDD VSS inv
XN3 A[0] A[1] A2B A3B N3 VDD VSS nand4
XO3 N3 Y[3] VDD VSS inv
XN4 A0B A1B A[2] A3B N4 VDD VSS nand4
XO4 N4 Y[4] VDD VSS inv
XN5 A[0] A1B A[2] A3B N5 VDD VSS nand4
XO5 N5 Y[5] VDD VSS inv
XN6 A0B A[1] A[2] A3B N6 VDD VSS nand4
XO6 N6 Y[6] VDD VSS inv
XN7 A[0] A[1] A[2] A3B N7 VDD VSS nand4
XO7 N7 Y[7] VDD VSS inv
XN8 A0B A1B A2B A[3] N8 VDD VSS nand4
XO8 N8 Y[8] VDD VSS inv
XN9 A[0] A1B A2B A[3] N9 VDD VSS nand4
XO9 N9 Y[9] VDD VSS inv
XN10 A0B A[1] A2B A[3] N10 VDD VSS nand4
XO10 N10 Y[10] VDD VSS inv
XN11 A[0] A[1] A2B A[3] N11 VDD VSS nand4
XO11 N11 Y[11] VDD VSS inv
XN12 A0B A1B A[2] A[3] N12 VDD VSS nand4
XO12 N12 Y[12] VDD VSS inv
XN13 A[0] A1B A[2] A[3] N13 VDD VSS nand4
XO13 N13 Y[13] VDD VSS inv
XN14 A0B A[1] A[2] A[3] N14 VDD VSS nand4
XO14 N14 Y[14] VDD VSS inv
XN15 A[0] A[1] A[2] A[3] N15 VDD VSS nand4
XO15 N15 Y[15] VDD VSS inv
**** begin user architecture code

* 4-to-16 predecoder, active-high one-hot Y[j], j = A[3:0]

**** end user architecture code
.ends

* expanding   symbol:  decoder/wl_drivers.sym # of pins=155
** sym_path: design/decoder/wl_drivers.sym
** sch_path: design/decoder/wl_drivers.sch
.subckt wl_drivers X[7] X[6] X[5] X[4] X[3] X[2] X[1] X[0] Y[15] Y[14] Y[13] Y[12] Y[11] Y[10] Y[9] Y[8] Y[7] Y[6] Y[5] Y[4] Y[3]
+ Y[2] Y[1] Y[0] WLEN WL[127] WL[126] WL[125] WL[124] WL[123] WL[122] WL[121] WL[120] WL[119] WL[118] WL[117] WL[116] WL[115] WL[114]
+ WL[113] WL[112] WL[111] WL[110] WL[109] WL[108] WL[107] WL[106] WL[105] WL[104] WL[103] WL[102] WL[101] WL[100] WL[99] WL[98] WL[97]
+ WL[96] WL[95] WL[94] WL[93] WL[92] WL[91] WL[90] WL[89] WL[88] WL[87] WL[86] WL[85] WL[84] WL[83] WL[82] WL[81] WL[80] WL[79] WL[78]
+ WL[77] WL[76] WL[75] WL[74] WL[73] WL[72] WL[71] WL[70] WL[69] WL[68] WL[67] WL[66] WL[65] WL[64] WL[63] WL[62] WL[61] WL[60] WL[59]
+ WL[58] WL[57] WL[56] WL[55] WL[54] WL[53] WL[52] WL[51] WL[50] WL[49] WL[48] WL[47] WL[46] WL[45] WL[44] WL[43] WL[42] WL[41] WL[40]
+ WL[39] WL[38] WL[37] WL[36] WL[35] WL[34] WL[33] WL[32] WL[31] WL[30] WL[29] WL[28] WL[27] WL[26] WL[25] WL[24] WL[23] WL[22] WL[21]
+ WL[20] WL[19] WL[18] WL[17] WL[16] WL[15] WL[14] WL[13] WL[12] WL[11] WL[10] WL[9] WL[8] WL[7] WL[6] WL[5] WL[4] WL[3] WL[2] WL[1] WL[0]
+ VDD VSS
*.ipin X[7]
*.ipin X[6]
*.ipin X[5]
*.ipin X[4]
*.ipin X[3]
*.ipin X[2]
*.ipin X[1]
*.ipin X[0]
*.ipin Y[15]
*.ipin Y[14]
*.ipin Y[13]
*.ipin Y[12]
*.ipin Y[11]
*.ipin Y[10]
*.ipin Y[9]
*.ipin Y[8]
*.ipin Y[7]
*.ipin Y[6]
*.ipin Y[5]
*.ipin Y[4]
*.ipin Y[3]
*.ipin Y[2]
*.ipin Y[1]
*.ipin Y[0]
*.ipin WLEN
*.opin WL[127]
*.opin WL[126]
*.opin WL[125]
*.opin WL[124]
*.opin WL[123]
*.opin WL[122]
*.opin WL[121]
*.opin WL[120]
*.opin WL[119]
*.opin WL[118]
*.opin WL[117]
*.opin WL[116]
*.opin WL[115]
*.opin WL[114]
*.opin WL[113]
*.opin WL[112]
*.opin WL[111]
*.opin WL[110]
*.opin WL[109]
*.opin WL[108]
*.opin WL[107]
*.opin WL[106]
*.opin WL[105]
*.opin WL[104]
*.opin WL[103]
*.opin WL[102]
*.opin WL[101]
*.opin WL[100]
*.opin WL[99]
*.opin WL[98]
*.opin WL[97]
*.opin WL[96]
*.opin WL[95]
*.opin WL[94]
*.opin WL[93]
*.opin WL[92]
*.opin WL[91]
*.opin WL[90]
*.opin WL[89]
*.opin WL[88]
*.opin WL[87]
*.opin WL[86]
*.opin WL[85]
*.opin WL[84]
*.opin WL[83]
*.opin WL[82]
*.opin WL[81]
*.opin WL[80]
*.opin WL[79]
*.opin WL[78]
*.opin WL[77]
*.opin WL[76]
*.opin WL[75]
*.opin WL[74]
*.opin WL[73]
*.opin WL[72]
*.opin WL[71]
*.opin WL[70]
*.opin WL[69]
*.opin WL[68]
*.opin WL[67]
*.opin WL[66]
*.opin WL[65]
*.opin WL[64]
*.opin WL[63]
*.opin WL[62]
*.opin WL[61]
*.opin WL[60]
*.opin WL[59]
*.opin WL[58]
*.opin WL[57]
*.opin WL[56]
*.opin WL[55]
*.opin WL[54]
*.opin WL[53]
*.opin WL[52]
*.opin WL[51]
*.opin WL[50]
*.opin WL[49]
*.opin WL[48]
*.opin WL[47]
*.opin WL[46]
*.opin WL[45]
*.opin WL[44]
*.opin WL[43]
*.opin WL[42]
*.opin WL[41]
*.opin WL[40]
*.opin WL[39]
*.opin WL[38]
*.opin WL[37]
*.opin WL[36]
*.opin WL[35]
*.opin WL[34]
*.opin WL[33]
*.opin WL[32]
*.opin WL[31]
*.opin WL[30]
*.opin WL[29]
*.opin WL[28]
*.opin WL[27]
*.opin WL[26]
*.opin WL[25]
*.opin WL[24]
*.opin WL[23]
*.opin WL[22]
*.opin WL[21]
*.opin WL[20]
*.opin WL[19]
*.opin WL[18]
*.opin WL[17]
*.opin WL[16]
*.opin WL[15]
*.opin WL[14]
*.opin WL[13]
*.opin WL[12]
*.opin WL[11]
*.opin WL[10]
*.opin WL[9]
*.opin WL[8]
*.opin WL[7]
*.opin WL[6]
*.opin WL[5]
*.opin WL[4]
*.opin WL[3]
*.opin WL[2]
*.opin WL[1]
*.opin WL[0]
*.iopin VDD
*.iopin VSS
XD[127] X[7] Y[15] WLEN WL[127] VDD VSS wl_driver
XD[126] X[6] Y[15] WLEN WL[126] VDD VSS wl_driver
XD[125] X[5] Y[15] WLEN WL[125] VDD VSS wl_driver
XD[124] X[4] Y[15] WLEN WL[124] VDD VSS wl_driver
XD[123] X[3] Y[15] WLEN WL[123] VDD VSS wl_driver
XD[122] X[2] Y[15] WLEN WL[122] VDD VSS wl_driver
XD[121] X[1] Y[15] WLEN WL[121] VDD VSS wl_driver
XD[120] X[0] Y[15] WLEN WL[120] VDD VSS wl_driver
XD[119] X[7] Y[14] WLEN WL[119] VDD VSS wl_driver
XD[118] X[6] Y[14] WLEN WL[118] VDD VSS wl_driver
XD[117] X[5] Y[14] WLEN WL[117] VDD VSS wl_driver
XD[116] X[4] Y[14] WLEN WL[116] VDD VSS wl_driver
XD[115] X[3] Y[14] WLEN WL[115] VDD VSS wl_driver
XD[114] X[2] Y[14] WLEN WL[114] VDD VSS wl_driver
XD[113] X[1] Y[14] WLEN WL[113] VDD VSS wl_driver
XD[112] X[0] Y[14] WLEN WL[112] VDD VSS wl_driver
XD[111] X[7] Y[13] WLEN WL[111] VDD VSS wl_driver
XD[110] X[6] Y[13] WLEN WL[110] VDD VSS wl_driver
XD[109] X[5] Y[13] WLEN WL[109] VDD VSS wl_driver
XD[108] X[4] Y[13] WLEN WL[108] VDD VSS wl_driver
XD[107] X[3] Y[13] WLEN WL[107] VDD VSS wl_driver
XD[106] X[2] Y[13] WLEN WL[106] VDD VSS wl_driver
XD[105] X[1] Y[13] WLEN WL[105] VDD VSS wl_driver
XD[104] X[0] Y[13] WLEN WL[104] VDD VSS wl_driver
XD[103] X[7] Y[12] WLEN WL[103] VDD VSS wl_driver
XD[102] X[6] Y[12] WLEN WL[102] VDD VSS wl_driver
XD[101] X[5] Y[12] WLEN WL[101] VDD VSS wl_driver
XD[100] X[4] Y[12] WLEN WL[100] VDD VSS wl_driver
XD[99] X[3] Y[12] WLEN WL[99] VDD VSS wl_driver
XD[98] X[2] Y[12] WLEN WL[98] VDD VSS wl_driver
XD[97] X[1] Y[12] WLEN WL[97] VDD VSS wl_driver
XD[96] X[0] Y[12] WLEN WL[96] VDD VSS wl_driver
XD[95] X[7] Y[11] WLEN WL[95] VDD VSS wl_driver
XD[94] X[6] Y[11] WLEN WL[94] VDD VSS wl_driver
XD[93] X[5] Y[11] WLEN WL[93] VDD VSS wl_driver
XD[92] X[4] Y[11] WLEN WL[92] VDD VSS wl_driver
XD[91] X[3] Y[11] WLEN WL[91] VDD VSS wl_driver
XD[90] X[2] Y[11] WLEN WL[90] VDD VSS wl_driver
XD[89] X[1] Y[11] WLEN WL[89] VDD VSS wl_driver
XD[88] X[0] Y[11] WLEN WL[88] VDD VSS wl_driver
XD[87] X[7] Y[10] WLEN WL[87] VDD VSS wl_driver
XD[86] X[6] Y[10] WLEN WL[86] VDD VSS wl_driver
XD[85] X[5] Y[10] WLEN WL[85] VDD VSS wl_driver
XD[84] X[4] Y[10] WLEN WL[84] VDD VSS wl_driver
XD[83] X[3] Y[10] WLEN WL[83] VDD VSS wl_driver
XD[82] X[2] Y[10] WLEN WL[82] VDD VSS wl_driver
XD[81] X[1] Y[10] WLEN WL[81] VDD VSS wl_driver
XD[80] X[0] Y[10] WLEN WL[80] VDD VSS wl_driver
XD[79] X[7] Y[9] WLEN WL[79] VDD VSS wl_driver
XD[78] X[6] Y[9] WLEN WL[78] VDD VSS wl_driver
XD[77] X[5] Y[9] WLEN WL[77] VDD VSS wl_driver
XD[76] X[4] Y[9] WLEN WL[76] VDD VSS wl_driver
XD[75] X[3] Y[9] WLEN WL[75] VDD VSS wl_driver
XD[74] X[2] Y[9] WLEN WL[74] VDD VSS wl_driver
XD[73] X[1] Y[9] WLEN WL[73] VDD VSS wl_driver
XD[72] X[0] Y[9] WLEN WL[72] VDD VSS wl_driver
XD[71] X[7] Y[8] WLEN WL[71] VDD VSS wl_driver
XD[70] X[6] Y[8] WLEN WL[70] VDD VSS wl_driver
XD[69] X[5] Y[8] WLEN WL[69] VDD VSS wl_driver
XD[68] X[4] Y[8] WLEN WL[68] VDD VSS wl_driver
XD[67] X[3] Y[8] WLEN WL[67] VDD VSS wl_driver
XD[66] X[2] Y[8] WLEN WL[66] VDD VSS wl_driver
XD[65] X[1] Y[8] WLEN WL[65] VDD VSS wl_driver
XD[64] X[0] Y[8] WLEN WL[64] VDD VSS wl_driver
XD[63] X[7] Y[7] WLEN WL[63] VDD VSS wl_driver
XD[62] X[6] Y[7] WLEN WL[62] VDD VSS wl_driver
XD[61] X[5] Y[7] WLEN WL[61] VDD VSS wl_driver
XD[60] X[4] Y[7] WLEN WL[60] VDD VSS wl_driver
XD[59] X[3] Y[7] WLEN WL[59] VDD VSS wl_driver
XD[58] X[2] Y[7] WLEN WL[58] VDD VSS wl_driver
XD[57] X[1] Y[7] WLEN WL[57] VDD VSS wl_driver
XD[56] X[0] Y[7] WLEN WL[56] VDD VSS wl_driver
XD[55] X[7] Y[6] WLEN WL[55] VDD VSS wl_driver
XD[54] X[6] Y[6] WLEN WL[54] VDD VSS wl_driver
XD[53] X[5] Y[6] WLEN WL[53] VDD VSS wl_driver
XD[52] X[4] Y[6] WLEN WL[52] VDD VSS wl_driver
XD[51] X[3] Y[6] WLEN WL[51] VDD VSS wl_driver
XD[50] X[2] Y[6] WLEN WL[50] VDD VSS wl_driver
XD[49] X[1] Y[6] WLEN WL[49] VDD VSS wl_driver
XD[48] X[0] Y[6] WLEN WL[48] VDD VSS wl_driver
XD[47] X[7] Y[5] WLEN WL[47] VDD VSS wl_driver
XD[46] X[6] Y[5] WLEN WL[46] VDD VSS wl_driver
XD[45] X[5] Y[5] WLEN WL[45] VDD VSS wl_driver
XD[44] X[4] Y[5] WLEN WL[44] VDD VSS wl_driver
XD[43] X[3] Y[5] WLEN WL[43] VDD VSS wl_driver
XD[42] X[2] Y[5] WLEN WL[42] VDD VSS wl_driver
XD[41] X[1] Y[5] WLEN WL[41] VDD VSS wl_driver
XD[40] X[0] Y[5] WLEN WL[40] VDD VSS wl_driver
XD[39] X[7] Y[4] WLEN WL[39] VDD VSS wl_driver
XD[38] X[6] Y[4] WLEN WL[38] VDD VSS wl_driver
XD[37] X[5] Y[4] WLEN WL[37] VDD VSS wl_driver
XD[36] X[4] Y[4] WLEN WL[36] VDD VSS wl_driver
XD[35] X[3] Y[4] WLEN WL[35] VDD VSS wl_driver
XD[34] X[2] Y[4] WLEN WL[34] VDD VSS wl_driver
XD[33] X[1] Y[4] WLEN WL[33] VDD VSS wl_driver
XD[32] X[0] Y[4] WLEN WL[32] VDD VSS wl_driver
XD[31] X[7] Y[3] WLEN WL[31] VDD VSS wl_driver
XD[30] X[6] Y[3] WLEN WL[30] VDD VSS wl_driver
XD[29] X[5] Y[3] WLEN WL[29] VDD VSS wl_driver
XD[28] X[4] Y[3] WLEN WL[28] VDD VSS wl_driver
XD[27] X[3] Y[3] WLEN WL[27] VDD VSS wl_driver
XD[26] X[2] Y[3] WLEN WL[26] VDD VSS wl_driver
XD[25] X[1] Y[3] WLEN WL[25] VDD VSS wl_driver
XD[24] X[0] Y[3] WLEN WL[24] VDD VSS wl_driver
XD[23] X[7] Y[2] WLEN WL[23] VDD VSS wl_driver
XD[22] X[6] Y[2] WLEN WL[22] VDD VSS wl_driver
XD[21] X[5] Y[2] WLEN WL[21] VDD VSS wl_driver
XD[20] X[4] Y[2] WLEN WL[20] VDD VSS wl_driver
XD[19] X[3] Y[2] WLEN WL[19] VDD VSS wl_driver
XD[18] X[2] Y[2] WLEN WL[18] VDD VSS wl_driver
XD[17] X[1] Y[2] WLEN WL[17] VDD VSS wl_driver
XD[16] X[0] Y[2] WLEN WL[16] VDD VSS wl_driver
XD[15] X[7] Y[1] WLEN WL[15] VDD VSS wl_driver
XD[14] X[6] Y[1] WLEN WL[14] VDD VSS wl_driver
XD[13] X[5] Y[1] WLEN WL[13] VDD VSS wl_driver
XD[12] X[4] Y[1] WLEN WL[12] VDD VSS wl_driver
XD[11] X[3] Y[1] WLEN WL[11] VDD VSS wl_driver
XD[10] X[2] Y[1] WLEN WL[10] VDD VSS wl_driver
XD[9] X[1] Y[1] WLEN WL[9] VDD VSS wl_driver
XD[8] X[0] Y[1] WLEN WL[8] VDD VSS wl_driver
XD[7] X[7] Y[0] WLEN WL[7] VDD VSS wl_driver
XD[6] X[6] Y[0] WLEN WL[6] VDD VSS wl_driver
XD[5] X[5] Y[0] WLEN WL[5] VDD VSS wl_driver
XD[4] X[4] Y[0] WLEN WL[4] VDD VSS wl_driver
XD[3] X[3] Y[0] WLEN WL[3] VDD VSS wl_driver
XD[2] X[2] Y[0] WLEN WL[2] VDD VSS wl_driver
XD[1] X[1] Y[0] WLEN WL[1] VDD VSS wl_driver
XD[0] X[0] Y[0] WLEN WL[0] VDD VSS wl_driver
**** begin user architecture code

* 128 wordline drivers; row r = 8*j + k is driven by X[k] and Y[j]

**** end user architecture code
.ends

* expanding   symbol:  macro/bl_pair.sym # of pins=132
** sym_path: design/macro/bl_pair.sym
** sch_path: design/macro/bl_pair.sch
.subckt bl_pair WL[127] WL[126] WL[125] WL[124] WL[123] WL[122] WL[121] WL[120] WL[119] WL[118] WL[117] WL[116] WL[115] WL[114]
+ WL[113] WL[112] WL[111] WL[110] WL[109] WL[108] WL[107] WL[106] WL[105] WL[104] WL[103] WL[102] WL[101] WL[100] WL[99] WL[98] WL[97]
+ WL[96] WL[95] WL[94] WL[93] WL[92] WL[91] WL[90] WL[89] WL[88] WL[87] WL[86] WL[85] WL[84] WL[83] WL[82] WL[81] WL[80] WL[79] WL[78]
+ WL[77] WL[76] WL[75] WL[74] WL[73] WL[72] WL[71] WL[70] WL[69] WL[68] WL[67] WL[66] WL[65] WL[64] WL[63] WL[62] WL[61] WL[60] WL[59]
+ WL[58] WL[57] WL[56] WL[55] WL[54] WL[53] WL[52] WL[51] WL[50] WL[49] WL[48] WL[47] WL[46] WL[45] WL[44] WL[43] WL[42] WL[41] WL[40]
+ WL[39] WL[38] WL[37] WL[36] WL[35] WL[34] WL[33] WL[32] WL[31] WL[30] WL[29] WL[28] WL[27] WL[26] WL[25] WL[24] WL[23] WL[22] WL[21]
+ WL[20] WL[19] WL[18] WL[17] WL[16] WL[15] WL[14] WL[13] WL[12] WL[11] WL[10] WL[9] WL[8] WL[7] WL[6] WL[5] WL[4] WL[3] WL[2] WL[1] WL[0]
+ BL BLB VDD VSS
*.ipin WL[127]
*.ipin WL[126]
*.ipin WL[125]
*.ipin WL[124]
*.ipin WL[123]
*.ipin WL[122]
*.ipin WL[121]
*.ipin WL[120]
*.ipin WL[119]
*.ipin WL[118]
*.ipin WL[117]
*.ipin WL[116]
*.ipin WL[115]
*.ipin WL[114]
*.ipin WL[113]
*.ipin WL[112]
*.ipin WL[111]
*.ipin WL[110]
*.ipin WL[109]
*.ipin WL[108]
*.ipin WL[107]
*.ipin WL[106]
*.ipin WL[105]
*.ipin WL[104]
*.ipin WL[103]
*.ipin WL[102]
*.ipin WL[101]
*.ipin WL[100]
*.ipin WL[99]
*.ipin WL[98]
*.ipin WL[97]
*.ipin WL[96]
*.ipin WL[95]
*.ipin WL[94]
*.ipin WL[93]
*.ipin WL[92]
*.ipin WL[91]
*.ipin WL[90]
*.ipin WL[89]
*.ipin WL[88]
*.ipin WL[87]
*.ipin WL[86]
*.ipin WL[85]
*.ipin WL[84]
*.ipin WL[83]
*.ipin WL[82]
*.ipin WL[81]
*.ipin WL[80]
*.ipin WL[79]
*.ipin WL[78]
*.ipin WL[77]
*.ipin WL[76]
*.ipin WL[75]
*.ipin WL[74]
*.ipin WL[73]
*.ipin WL[72]
*.ipin WL[71]
*.ipin WL[70]
*.ipin WL[69]
*.ipin WL[68]
*.ipin WL[67]
*.ipin WL[66]
*.ipin WL[65]
*.ipin WL[64]
*.ipin WL[63]
*.ipin WL[62]
*.ipin WL[61]
*.ipin WL[60]
*.ipin WL[59]
*.ipin WL[58]
*.ipin WL[57]
*.ipin WL[56]
*.ipin WL[55]
*.ipin WL[54]
*.ipin WL[53]
*.ipin WL[52]
*.ipin WL[51]
*.ipin WL[50]
*.ipin WL[49]
*.ipin WL[48]
*.ipin WL[47]
*.ipin WL[46]
*.ipin WL[45]
*.ipin WL[44]
*.ipin WL[43]
*.ipin WL[42]
*.ipin WL[41]
*.ipin WL[40]
*.ipin WL[39]
*.ipin WL[38]
*.ipin WL[37]
*.ipin WL[36]
*.ipin WL[35]
*.ipin WL[34]
*.ipin WL[33]
*.ipin WL[32]
*.ipin WL[31]
*.ipin WL[30]
*.ipin WL[29]
*.ipin WL[28]
*.ipin WL[27]
*.ipin WL[26]
*.ipin WL[25]
*.ipin WL[24]
*.ipin WL[23]
*.ipin WL[22]
*.ipin WL[21]
*.ipin WL[20]
*.ipin WL[19]
*.ipin WL[18]
*.ipin WL[17]
*.ipin WL[16]
*.ipin WL[15]
*.ipin WL[14]
*.ipin WL[13]
*.ipin WL[12]
*.ipin WL[11]
*.ipin WL[10]
*.ipin WL[9]
*.ipin WL[8]
*.ipin WL[7]
*.ipin WL[6]
*.ipin WL[5]
*.ipin WL[4]
*.ipin WL[3]
*.ipin WL[2]
*.ipin WL[1]
*.ipin WL[0]
*.iopin BL
*.iopin BLB
*.iopin VDD
*.iopin VSS
XB[127] BL BLB WL[127] VDD VSS Q[127] QB[127] bitcell
XB[126] BL BLB WL[126] VDD VSS Q[126] QB[126] bitcell
XB[125] BL BLB WL[125] VDD VSS Q[125] QB[125] bitcell
XB[124] BL BLB WL[124] VDD VSS Q[124] QB[124] bitcell
XB[123] BL BLB WL[123] VDD VSS Q[123] QB[123] bitcell
XB[122] BL BLB WL[122] VDD VSS Q[122] QB[122] bitcell
XB[121] BL BLB WL[121] VDD VSS Q[121] QB[121] bitcell
XB[120] BL BLB WL[120] VDD VSS Q[120] QB[120] bitcell
XB[119] BL BLB WL[119] VDD VSS Q[119] QB[119] bitcell
XB[118] BL BLB WL[118] VDD VSS Q[118] QB[118] bitcell
XB[117] BL BLB WL[117] VDD VSS Q[117] QB[117] bitcell
XB[116] BL BLB WL[116] VDD VSS Q[116] QB[116] bitcell
XB[115] BL BLB WL[115] VDD VSS Q[115] QB[115] bitcell
XB[114] BL BLB WL[114] VDD VSS Q[114] QB[114] bitcell
XB[113] BL BLB WL[113] VDD VSS Q[113] QB[113] bitcell
XB[112] BL BLB WL[112] VDD VSS Q[112] QB[112] bitcell
XB[111] BL BLB WL[111] VDD VSS Q[111] QB[111] bitcell
XB[110] BL BLB WL[110] VDD VSS Q[110] QB[110] bitcell
XB[109] BL BLB WL[109] VDD VSS Q[109] QB[109] bitcell
XB[108] BL BLB WL[108] VDD VSS Q[108] QB[108] bitcell
XB[107] BL BLB WL[107] VDD VSS Q[107] QB[107] bitcell
XB[106] BL BLB WL[106] VDD VSS Q[106] QB[106] bitcell
XB[105] BL BLB WL[105] VDD VSS Q[105] QB[105] bitcell
XB[104] BL BLB WL[104] VDD VSS Q[104] QB[104] bitcell
XB[103] BL BLB WL[103] VDD VSS Q[103] QB[103] bitcell
XB[102] BL BLB WL[102] VDD VSS Q[102] QB[102] bitcell
XB[101] BL BLB WL[101] VDD VSS Q[101] QB[101] bitcell
XB[100] BL BLB WL[100] VDD VSS Q[100] QB[100] bitcell
XB[99] BL BLB WL[99] VDD VSS Q[99] QB[99] bitcell
XB[98] BL BLB WL[98] VDD VSS Q[98] QB[98] bitcell
XB[97] BL BLB WL[97] VDD VSS Q[97] QB[97] bitcell
XB[96] BL BLB WL[96] VDD VSS Q[96] QB[96] bitcell
XB[95] BL BLB WL[95] VDD VSS Q[95] QB[95] bitcell
XB[94] BL BLB WL[94] VDD VSS Q[94] QB[94] bitcell
XB[93] BL BLB WL[93] VDD VSS Q[93] QB[93] bitcell
XB[92] BL BLB WL[92] VDD VSS Q[92] QB[92] bitcell
XB[91] BL BLB WL[91] VDD VSS Q[91] QB[91] bitcell
XB[90] BL BLB WL[90] VDD VSS Q[90] QB[90] bitcell
XB[89] BL BLB WL[89] VDD VSS Q[89] QB[89] bitcell
XB[88] BL BLB WL[88] VDD VSS Q[88] QB[88] bitcell
XB[87] BL BLB WL[87] VDD VSS Q[87] QB[87] bitcell
XB[86] BL BLB WL[86] VDD VSS Q[86] QB[86] bitcell
XB[85] BL BLB WL[85] VDD VSS Q[85] QB[85] bitcell
XB[84] BL BLB WL[84] VDD VSS Q[84] QB[84] bitcell
XB[83] BL BLB WL[83] VDD VSS Q[83] QB[83] bitcell
XB[82] BL BLB WL[82] VDD VSS Q[82] QB[82] bitcell
XB[81] BL BLB WL[81] VDD VSS Q[81] QB[81] bitcell
XB[80] BL BLB WL[80] VDD VSS Q[80] QB[80] bitcell
XB[79] BL BLB WL[79] VDD VSS Q[79] QB[79] bitcell
XB[78] BL BLB WL[78] VDD VSS Q[78] QB[78] bitcell
XB[77] BL BLB WL[77] VDD VSS Q[77] QB[77] bitcell
XB[76] BL BLB WL[76] VDD VSS Q[76] QB[76] bitcell
XB[75] BL BLB WL[75] VDD VSS Q[75] QB[75] bitcell
XB[74] BL BLB WL[74] VDD VSS Q[74] QB[74] bitcell
XB[73] BL BLB WL[73] VDD VSS Q[73] QB[73] bitcell
XB[72] BL BLB WL[72] VDD VSS Q[72] QB[72] bitcell
XB[71] BL BLB WL[71] VDD VSS Q[71] QB[71] bitcell
XB[70] BL BLB WL[70] VDD VSS Q[70] QB[70] bitcell
XB[69] BL BLB WL[69] VDD VSS Q[69] QB[69] bitcell
XB[68] BL BLB WL[68] VDD VSS Q[68] QB[68] bitcell
XB[67] BL BLB WL[67] VDD VSS Q[67] QB[67] bitcell
XB[66] BL BLB WL[66] VDD VSS Q[66] QB[66] bitcell
XB[65] BL BLB WL[65] VDD VSS Q[65] QB[65] bitcell
XB[64] BL BLB WL[64] VDD VSS Q[64] QB[64] bitcell
XB[63] BL BLB WL[63] VDD VSS Q[63] QB[63] bitcell
XB[62] BL BLB WL[62] VDD VSS Q[62] QB[62] bitcell
XB[61] BL BLB WL[61] VDD VSS Q[61] QB[61] bitcell
XB[60] BL BLB WL[60] VDD VSS Q[60] QB[60] bitcell
XB[59] BL BLB WL[59] VDD VSS Q[59] QB[59] bitcell
XB[58] BL BLB WL[58] VDD VSS Q[58] QB[58] bitcell
XB[57] BL BLB WL[57] VDD VSS Q[57] QB[57] bitcell
XB[56] BL BLB WL[56] VDD VSS Q[56] QB[56] bitcell
XB[55] BL BLB WL[55] VDD VSS Q[55] QB[55] bitcell
XB[54] BL BLB WL[54] VDD VSS Q[54] QB[54] bitcell
XB[53] BL BLB WL[53] VDD VSS Q[53] QB[53] bitcell
XB[52] BL BLB WL[52] VDD VSS Q[52] QB[52] bitcell
XB[51] BL BLB WL[51] VDD VSS Q[51] QB[51] bitcell
XB[50] BL BLB WL[50] VDD VSS Q[50] QB[50] bitcell
XB[49] BL BLB WL[49] VDD VSS Q[49] QB[49] bitcell
XB[48] BL BLB WL[48] VDD VSS Q[48] QB[48] bitcell
XB[47] BL BLB WL[47] VDD VSS Q[47] QB[47] bitcell
XB[46] BL BLB WL[46] VDD VSS Q[46] QB[46] bitcell
XB[45] BL BLB WL[45] VDD VSS Q[45] QB[45] bitcell
XB[44] BL BLB WL[44] VDD VSS Q[44] QB[44] bitcell
XB[43] BL BLB WL[43] VDD VSS Q[43] QB[43] bitcell
XB[42] BL BLB WL[42] VDD VSS Q[42] QB[42] bitcell
XB[41] BL BLB WL[41] VDD VSS Q[41] QB[41] bitcell
XB[40] BL BLB WL[40] VDD VSS Q[40] QB[40] bitcell
XB[39] BL BLB WL[39] VDD VSS Q[39] QB[39] bitcell
XB[38] BL BLB WL[38] VDD VSS Q[38] QB[38] bitcell
XB[37] BL BLB WL[37] VDD VSS Q[37] QB[37] bitcell
XB[36] BL BLB WL[36] VDD VSS Q[36] QB[36] bitcell
XB[35] BL BLB WL[35] VDD VSS Q[35] QB[35] bitcell
XB[34] BL BLB WL[34] VDD VSS Q[34] QB[34] bitcell
XB[33] BL BLB WL[33] VDD VSS Q[33] QB[33] bitcell
XB[32] BL BLB WL[32] VDD VSS Q[32] QB[32] bitcell
XB[31] BL BLB WL[31] VDD VSS Q[31] QB[31] bitcell
XB[30] BL BLB WL[30] VDD VSS Q[30] QB[30] bitcell
XB[29] BL BLB WL[29] VDD VSS Q[29] QB[29] bitcell
XB[28] BL BLB WL[28] VDD VSS Q[28] QB[28] bitcell
XB[27] BL BLB WL[27] VDD VSS Q[27] QB[27] bitcell
XB[26] BL BLB WL[26] VDD VSS Q[26] QB[26] bitcell
XB[25] BL BLB WL[25] VDD VSS Q[25] QB[25] bitcell
XB[24] BL BLB WL[24] VDD VSS Q[24] QB[24] bitcell
XB[23] BL BLB WL[23] VDD VSS Q[23] QB[23] bitcell
XB[22] BL BLB WL[22] VDD VSS Q[22] QB[22] bitcell
XB[21] BL BLB WL[21] VDD VSS Q[21] QB[21] bitcell
XB[20] BL BLB WL[20] VDD VSS Q[20] QB[20] bitcell
XB[19] BL BLB WL[19] VDD VSS Q[19] QB[19] bitcell
XB[18] BL BLB WL[18] VDD VSS Q[18] QB[18] bitcell
XB[17] BL BLB WL[17] VDD VSS Q[17] QB[17] bitcell
XB[16] BL BLB WL[16] VDD VSS Q[16] QB[16] bitcell
XB[15] BL BLB WL[15] VDD VSS Q[15] QB[15] bitcell
XB[14] BL BLB WL[14] VDD VSS Q[14] QB[14] bitcell
XB[13] BL BLB WL[13] VDD VSS Q[13] QB[13] bitcell
XB[12] BL BLB WL[12] VDD VSS Q[12] QB[12] bitcell
XB[11] BL BLB WL[11] VDD VSS Q[11] QB[11] bitcell
XB[10] BL BLB WL[10] VDD VSS Q[10] QB[10] bitcell
XB[9] BL BLB WL[9] VDD VSS Q[9] QB[9] bitcell
XB[8] BL BLB WL[8] VDD VSS Q[8] QB[8] bitcell
XB[7] BL BLB WL[7] VDD VSS Q[7] QB[7] bitcell
XB[6] BL BLB WL[6] VDD VSS Q[6] QB[6] bitcell
XB[5] BL BLB WL[5] VDD VSS Q[5] QB[5] bitcell
XB[4] BL BLB WL[4] VDD VSS Q[4] QB[4] bitcell
XB[3] BL BLB WL[3] VDD VSS Q[3] QB[3] bitcell
XB[2] BL BLB WL[2] VDD VSS Q[2] QB[2] bitcell
XB[1] BL BLB WL[1] VDD VSS Q[1] QB[1] bitcell
XB[0] BL BLB WL[0] VDD VSS Q[0] QB[0] bitcell
**** begin user architecture code

* one bit-line pair: the 128 bitcells of a physical column, one per wordline

**** end user architecture code
.ends

* expanding   symbol:  column/precharge.sym # of pins=5
** sym_path: design/column/precharge.sym
** sch_path: design/column/precharge.sch
.subckt precharge PRE_B BL BLB VDD VSS
*.ipin PRE_B
*.iopin BL
*.iopin BLB
*.iopin VDD
*.iopin VSS
XMP0 BL PRE_B VDD VDD sg13_lv_pmos w=1.0u l=0.13u ng=1 m=1
XMP1 BLB PRE_B VDD VDD sg13_lv_pmos w=1.0u l=0.13u ng=1 m=1
XMP2 BL PRE_B BLB VDD sg13_lv_pmos w=1.0u l=0.13u ng=1 m=1
**** begin user architecture code

* bit-line precharge to VDD and equalize, active-low PRE_B

**** end user architecture code
.ends

* expanding   symbol:  column/column_mux.sym # of pins=12
** sym_path: design/column/column_mux.sym
** sch_path: design/column/column_mux.sch
.subckt column_mux SEL0 SEL0B SEL1 SEL1B BL0 BLB0 BL1 BLB1 BLM BLBM VDD VSS
*.ipin SEL0
*.ipin SEL0B
*.ipin SEL1
*.ipin SEL1B
*.iopin BL0
*.iopin BLB0
*.iopin BL1
*.iopin BLB1
*.iopin BLM
*.iopin BLBM
*.iopin VDD
*.iopin VSS
XMN0T BL0 SEL0 BLM VSS sg13_lv_nmos w=2.0u l=0.13u ng=1 m=1
XMP0T BL0 SEL0B BLM VDD sg13_lv_pmos w=2.0u l=0.13u ng=1 m=1
XMN0B BLB0 SEL0 BLBM VSS sg13_lv_nmos w=2.0u l=0.13u ng=1 m=1
XMP0B BLB0 SEL0B BLBM VDD sg13_lv_pmos w=2.0u l=0.13u ng=1 m=1
XMN1T BL1 SEL1 BLM VSS sg13_lv_nmos w=2.0u l=0.13u ng=1 m=1
XMP1T BL1 SEL1B BLM VDD sg13_lv_pmos w=2.0u l=0.13u ng=1 m=1
XMN1B BLB1 SEL1 BLBM VSS sg13_lv_nmos w=2.0u l=0.13u ng=1 m=1
XMP1B BLB1 SEL1B BLBM VDD sg13_lv_pmos w=2.0u l=0.13u ng=1 m=1
**** begin user architecture code

* 2:1 column mux: NMOS+PMOS transmission gates, SELn high / SELnB low selects column n

**** end user architecture code
.ends

* expanding   symbol:  column/sense_amp.sym # of pins=7
** sym_path: design/column/sense_amp.sym
** sch_path: design/column/sense_amp.sch
.subckt sense_amp SAE BLM BLBM OUT OUTB VDD VSS
*.ipin SAE
*.iopin BLM
*.iopin BLBM
*.iopin OUT
*.iopin OUTB
*.iopin VDD
*.iopin VSS
XMPI0 OUT SAE BLM VDD sg13_lv_pmos w=2.0u l=0.13u ng=1 m=1
XMPI1 OUTB SAE BLBM VDD sg13_lv_pmos w=2.0u l=0.13u ng=1 m=1
XMPL0 OUT OUTB VDD VDD sg13_lv_pmos w=1.0u l=0.13u ng=1 m=1
XMPL1 OUTB OUT VDD VDD sg13_lv_pmos w=1.0u l=0.13u ng=1 m=1
XMNL0 OUT OUTB TAIL VSS sg13_lv_nmos w=1.0u l=0.13u ng=1 m=1
XMNL1 OUTB OUT TAIL VSS sg13_lv_nmos w=1.0u l=0.13u ng=1 m=1
XMNT TAIL SAE VSS VSS sg13_lv_nmos w=2.0u l=0.13u ng=1 m=1
**** begin user architecture code

* latch SA: SAE low = isolation PMOS pass bit lines to OUT/OUTB, SAE high = latch

**** end user architecture code
.ends

* expanding   symbol:  column/write_driver.sym # of pins=6
** sym_path: design/column/write_driver.sym
** sch_path: design/column/write_driver.sch
.subckt write_driver WE DIN BLM BLBM VDD VSS
*.ipin WE
*.ipin DIN
*.iopin BLM
*.iopin BLBM
*.iopin VDD
*.iopin VSS
XMPD DINB DIN VDD VDD sg13_lv_pmos w=0.5u l=0.13u ng=1 m=1
XMND DINB DIN VSS VSS sg13_lv_nmos w=0.5u l=0.13u ng=1 m=1
XMNA0 BLM DINB WA VSS sg13_lv_nmos w=3.0u l=0.13u ng=1 m=1
XMNA1 WA WE VSS VSS sg13_lv_nmos w=3.0u l=0.13u ng=1 m=1
XMNB0 BLBM DIN WB VSS sg13_lv_nmos w=3.0u l=0.13u ng=1 m=1
XMNB1 WB WE VSS VSS sg13_lv_nmos w=3.0u l=0.13u ng=1 m=1
**** begin user architecture code

* write driver: WE and DIN pull BLBM low, WE and DINB pull BLM low (cell Q takes DIN)

**** end user architecture code
.ends

* expanding   symbol:  gates/nand4.sym # of pins=7
** sym_path: design/gates/nand4.sym
** sch_path: design/gates/nand4.sch
.subckt nand4 A B C D Y VDD VSS
*.ipin A
*.ipin B
*.ipin C
*.ipin D
*.opin Y
*.iopin VDD
*.iopin VSS
XMP0 Y A VDD VDD sg13_lv_pmos w=1.0u l=0.13u ng=1 m=1
XMP1 Y B VDD VDD sg13_lv_pmos w=1.0u l=0.13u ng=1 m=1
XMP2 Y C VDD VDD sg13_lv_pmos w=1.0u l=0.13u ng=1 m=1
XMP3 Y D VDD VDD sg13_lv_pmos w=1.0u l=0.13u ng=1 m=1
XMN0 Y A N1 VSS sg13_lv_nmos w=2.0u l=0.13u ng=1 m=1
XMN1 N1 B N2 VSS sg13_lv_nmos w=2.0u l=0.13u ng=1 m=1
XMN2 N2 C N3 VSS sg13_lv_nmos w=2.0u l=0.13u ng=1 m=1
XMN3 N3 D VSS VSS sg13_lv_nmos w=2.0u l=0.13u ng=1 m=1
**** begin user architecture code

* 4-input NAND, N 2.0 um stack / P 1.0 um

**** end user architecture code
.ends

* expanding   symbol:  decoder/wl_driver.sym # of pins=6
** sym_path: design/decoder/wl_driver.sym
** sch_path: design/decoder/wl_driver.sch
.subckt wl_driver X Y WLEN WL VDD VSS
*.ipin X
*.ipin Y
*.ipin WLEN
*.opin WL
*.iopin VDD
*.iopin VSS
XMPA WLB X VDD VDD sg13_lv_pmos w=1.0u l=0.13u ng=1 m=1
XMPB WLB Y VDD VDD sg13_lv_pmos w=1.0u l=0.13u ng=1 m=1
XMPC WLB WLEN VDD VDD sg13_lv_pmos w=1.0u l=0.13u ng=1 m=1
XMNA WLB X N1 VSS sg13_lv_nmos w=1.5u l=0.13u ng=1 m=1
XMNB N1 Y N2 VSS sg13_lv_nmos w=1.5u l=0.13u ng=1 m=1
XMNC N2 WLEN VSS VSS sg13_lv_nmos w=1.5u l=0.13u ng=1 m=1
XMPD WL WLB VDD VDD sg13_lv_pmos w=4.0u l=0.13u ng=1 m=1
XMND WL WLB VSS VSS sg13_lv_nmos w=2.0u l=0.13u ng=1 m=1
**** begin user architecture code

* one wordline: NAND3(X, Y, WLEN) then a 4x inverter driving WL

**** end user architecture code
.ends

* expanding   symbol:  bitcell/bitcell.sym # of pins=7
** sym_path: design/bitcell/bitcell.sym
** sch_path: design/bitcell/bitcell.sch
.subckt bitcell BL BLB WL VDD VSS Q QB
*.iopin BL
*.iopin BLB
*.ipin WL
*.iopin VDD
*.iopin VSS
*.iopin Q
*.iopin QB
XMP0 Q QB VDD VDD sg13_lv_pmos w=0.15u l=0.13u ng=1 m=1
XMN0 Q QB VSS VSS sg13_lv_nmos w=0.30u l=0.13u ng=1 m=1
XMP1 QB Q VDD VDD sg13_lv_pmos w=0.15u l=0.13u ng=1 m=1
XMN1 QB Q VSS VSS sg13_lv_nmos w=0.30u l=0.13u ng=1 m=1
XMN2 BL WL Q VSS sg13_lv_nmos w=0.30u l=0.13u ng=1 m=1
XMN3 BLB WL QB VSS sg13_lv_nmos w=0.30u l=0.13u ng=1 m=1
**** begin user architecture code

* 6T SRAM bitcell, reference sizing from spec/bitcell-decision.md evidence 1

**** end user architecture code
.ends
