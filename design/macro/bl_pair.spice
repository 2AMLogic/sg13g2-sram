** sch_path: design/macro/bl_pair.sch

* one bit-line pair: the 128 bitcells of a physical column, one per wordline

.subckt bl_pair WL[127] WL[126] WL[125] WL[124] WL[123] WL[122] WL[121] WL[120] WL[119] WL[118] WL[117] WL[116] WL[115] WL[114]
+ WL[113] WL[112] WL[111] WL[110] WL[109] WL[108] WL[107] WL[106] WL[105] WL[104] WL[103] WL[102] WL[101] WL[100] WL[99] WL[98] WL[97]
+ WL[96] WL[95] WL[94] WL[93] WL[92] WL[91] WL[90] WL[89] WL[88] WL[87] WL[86] WL[85] WL[84] WL[83] WL[82] WL[81] WL[80] WL[79] WL[78]
+ WL[77] WL[76] WL[75] WL[74] WL[73] WL[72] WL[71] WL[70] WL[69] WL[68] WL[67] WL[66] WL[65] WL[64] WL[63] WL[62] WL[61] WL[60] WL[59]
+ WL[58] WL[57] WL[56] WL[55] WL[54] WL[53] WL[52] WL[51] WL[50] WL[49] WL[48] WL[47] WL[46] WL[45] WL[44] WL[43] WL[42] WL[41] WL[40]
+ WL[39] WL[38] WL[37] WL[36] WL[35] WL[34] WL[33] WL[32] WL[31] WL[30] WL[29] WL[28] WL[27] WL[26] WL[25] WL[24] WL[23] WL[22] WL[21]
+ WL[20] WL[19] WL[18] WL[17] WL[16] WL[15] WL[14] WL[13] WL[12] WL[11] WL[10] WL[9] WL[8] WL[7] WL[6] WL[5] WL[4] WL[3] WL[2] WL[1] WL[0]
+ BL BLB VDD VSS
*.ipin WL[127]
*.ipin WL[126]
*.ipin WL[125]
*.ipin WL[124]
*.ipin WL[123]
*.ipin WL[122]
*.ipin WL[121]
*.ipin WL[120]
*.ipin WL[119]
*.ipin WL[118]
*.ipin WL[117]
*.ipin WL[116]
*.ipin WL[115]
*.ipin WL[114]
*.ipin WL[113]
*.ipin WL[112]
*.ipin WL[111]
*.ipin WL[110]
*.ipin WL[109]
*.ipin WL[108]
*.ipin WL[107]
*.ipin WL[106]
*.ipin WL[105]
*.ipin WL[104]
*.ipin WL[103]
*.ipin WL[102]
*.ipin WL[101]
*.ipin WL[100]
*.ipin WL[99]
*.ipin WL[98]
*.ipin WL[97]
*.ipin WL[96]
*.ipin WL[95]
*.ipin WL[94]
*.ipin WL[93]
*.ipin WL[92]
*.ipin WL[91]
*.ipin WL[90]
*.ipin WL[89]
*.ipin WL[88]
*.ipin WL[87]
*.ipin WL[86]
*.ipin WL[85]
*.ipin WL[84]
*.ipin WL[83]
*.ipin WL[82]
*.ipin WL[81]
*.ipin WL[80]
*.ipin WL[79]
*.ipin WL[78]
*.ipin WL[77]
*.ipin WL[76]
*.ipin WL[75]
*.ipin WL[74]
*.ipin WL[73]
*.ipin WL[72]
*.ipin WL[71]
*.ipin WL[70]
*.ipin WL[69]
*.ipin WL[68]
*.ipin WL[67]
*.ipin WL[66]
*.ipin WL[65]
*.ipin WL[64]
*.ipin WL[63]
*.ipin WL[62]
*.ipin WL[61]
*.ipin WL[60]
*.ipin WL[59]
*.ipin WL[58]
*.ipin WL[57]
*.ipin WL[56]
*.ipin WL[55]
*.ipin WL[54]
*.ipin WL[53]
*.ipin WL[52]
*.ipin WL[51]
*.ipin WL[50]
*.ipin WL[49]
*.ipin WL[48]
*.ipin WL[47]
*.ipin WL[46]
*.ipin WL[45]
*.ipin WL[44]
*.ipin WL[43]
*.ipin WL[42]
*.ipin WL[41]
*.ipin WL[40]
*.ipin WL[39]
*.ipin WL[38]
*.ipin WL[37]
*.ipin WL[36]
*.ipin WL[35]
*.ipin WL[34]
*.ipin WL[33]
*.ipin WL[32]
*.ipin WL[31]
*.ipin WL[30]
*.ipin WL[29]
*.ipin WL[28]
*.ipin WL[27]
*.ipin WL[26]
*.ipin WL[25]
*.ipin WL[24]
*.ipin WL[23]
*.ipin WL[22]
*.ipin WL[21]
*.ipin WL[20]
*.ipin WL[19]
*.ipin WL[18]
*.ipin WL[17]
*.ipin WL[16]
*.ipin WL[15]
*.ipin WL[14]
*.ipin WL[13]
*.ipin WL[12]
*.ipin WL[11]
*.ipin WL[10]
*.ipin WL[9]
*.ipin WL[8]
*.ipin WL[7]
*.ipin WL[6]
*.ipin WL[5]
*.ipin WL[4]
*.ipin WL[3]
*.ipin WL[2]
*.ipin WL[1]
*.ipin WL[0]
*.iopin BL
*.iopin BLB
*.iopin VDD
*.iopin VSS
XB[127] BL BLB WL[127] VDD VSS Q[127] QB[127] bitcell
XB[126] BL BLB WL[126] VDD VSS Q[126] QB[126] bitcell
XB[125] BL BLB WL[125] VDD VSS Q[125] QB[125] bitcell
XB[124] BL BLB WL[124] VDD VSS Q[124] QB[124] bitcell
XB[123] BL BLB WL[123] VDD VSS Q[123] QB[123] bitcell
XB[122] BL BLB WL[122] VDD VSS Q[122] QB[122] bitcell
XB[121] BL BLB WL[121] VDD VSS Q[121] QB[121] bitcell
XB[120] BL BLB WL[120] VDD VSS Q[120] QB[120] bitcell
XB[119] BL BLB WL[119] VDD VSS Q[119] QB[119] bitcell
XB[118] BL BLB WL[118] VDD VSS Q[118] QB[118] bitcell
XB[117] BL BLB WL[117] VDD VSS Q[117] QB[117] bitcell
XB[116] BL BLB WL[116] VDD VSS Q[116] QB[116] bitcell
XB[115] BL BLB WL[115] VDD VSS Q[115] QB[115] bitcell
XB[114] BL BLB WL[114] VDD VSS Q[114] QB[114] bitcell
XB[113] BL BLB WL[113] VDD VSS Q[113] QB[113] bitcell
XB[112] BL BLB WL[112] VDD VSS Q[112] QB[112] bitcell
XB[111] BL BLB WL[111] VDD VSS Q[111] QB[111] bitcell
XB[110] BL BLB WL[110] VDD VSS Q[110] QB[110] bitcell
XB[109] BL BLB WL[109] VDD VSS Q[109] QB[109] bitcell
XB[108] BL BLB WL[108] VDD VSS Q[108] QB[108] bitcell
XB[107] BL BLB WL[107] VDD VSS Q[107] QB[107] bitcell
XB[106] BL BLB WL[106] VDD VSS Q[106] QB[106] bitcell
XB[105] BL BLB WL[105] VDD VSS Q[105] QB[105] bitcell
XB[104] BL BLB WL[104] VDD VSS Q[104] QB[104] bitcell
XB[103] BL BLB WL[103] VDD VSS Q[103] QB[103] bitcell
XB[102] BL BLB WL[102] VDD VSS Q[102] QB[102] bitcell
XB[101] BL BLB WL[101] VDD VSS Q[101] QB[101] bitcell
XB[100] BL BLB WL[100] VDD VSS Q[100] QB[100] bitcell
XB[99] BL BLB WL[99] VDD VSS Q[99] QB[99] bitcell
XB[98] BL BLB WL[98] VDD VSS Q[98] QB[98] bitcell
XB[97] BL BLB WL[97] VDD VSS Q[97] QB[97] bitcell
XB[96] BL BLB WL[96] VDD VSS Q[96] QB[96] bitcell
XB[95] BL BLB WL[95] VDD VSS Q[95] QB[95] bitcell
XB[94] BL BLB WL[94] VDD VSS Q[94] QB[94] bitcell
XB[93] BL BLB WL[93] VDD VSS Q[93] QB[93] bitcell
XB[92] BL BLB WL[92] VDD VSS Q[92] QB[92] bitcell
XB[91] BL BLB WL[91] VDD VSS Q[91] QB[91] bitcell
XB[90] BL BLB WL[90] VDD VSS Q[90] QB[90] bitcell
XB[89] BL BLB WL[89] VDD VSS Q[89] QB[89] bitcell
XB[88] BL BLB WL[88] VDD VSS Q[88] QB[88] bitcell
XB[87] BL BLB WL[87] VDD VSS Q[87] QB[87] bitcell
XB[86] BL BLB WL[86] VDD VSS Q[86] QB[86] bitcell
XB[85] BL BLB WL[85] VDD VSS Q[85] QB[85] bitcell
XB[84] BL BLB WL[84] VDD VSS Q[84] QB[84] bitcell
XB[83] BL BLB WL[83] VDD VSS Q[83] QB[83] bitcell
XB[82] BL BLB WL[82] VDD VSS Q[82] QB[82] bitcell
XB[81] BL BLB WL[81] VDD VSS Q[81] QB[81] bitcell
XB[80] BL BLB WL[80] VDD VSS Q[80] QB[80] bitcell
XB[79] BL BLB WL[79] VDD VSS Q[79] QB[79] bitcell
XB[78] BL BLB WL[78] VDD VSS Q[78] QB[78] bitcell
XB[77] BL BLB WL[77] VDD VSS Q[77] QB[77] bitcell
XB[76] BL BLB WL[76] VDD VSS Q[76] QB[76] bitcell
XB[75] BL BLB WL[75] VDD VSS Q[75] QB[75] bitcell
XB[74] BL BLB WL[74] VDD VSS Q[74] QB[74] bitcell
XB[73] BL BLB WL[73] VDD VSS Q[73] QB[73] bitcell
XB[72] BL BLB WL[72] VDD VSS Q[72] QB[72] bitcell
XB[71] BL BLB WL[71] VDD VSS Q[71] QB[71] bitcell
XB[70] BL BLB WL[70] VDD VSS Q[70] QB[70] bitcell
XB[69] BL BLB WL[69] VDD VSS Q[69] QB[69] bitcell
XB[68] BL BLB WL[68] VDD VSS Q[68] QB[68] bitcell
XB[67] BL BLB WL[67] VDD VSS Q[67] QB[67] bitcell
XB[66] BL BLB WL[66] VDD VSS Q[66] QB[66] bitcell
XB[65] BL BLB WL[65] VDD VSS Q[65] QB[65] bitcell
XB[64] BL BLB WL[64] VDD VSS Q[64] QB[64] bitcell
XB[63] BL BLB WL[63] VDD VSS Q[63] QB[63] bitcell
XB[62] BL BLB WL[62] VDD VSS Q[62] QB[62] bitcell
XB[61] BL BLB WL[61] VDD VSS Q[61] QB[61] bitcell
XB[60] BL BLB WL[60] VDD VSS Q[60] QB[60] bitcell
XB[59] BL BLB WL[59] VDD VSS Q[59] QB[59] bitcell
XB[58] BL BLB WL[58] VDD VSS Q[58] QB[58] bitcell
XB[57] BL BLB WL[57] VDD VSS Q[57] QB[57] bitcell
XB[56] BL BLB WL[56] VDD VSS Q[56] QB[56] bitcell
XB[55] BL BLB WL[55] VDD VSS Q[55] QB[55] bitcell
XB[54] BL BLB WL[54] VDD VSS Q[54] QB[54] bitcell
XB[53] BL BLB WL[53] VDD VSS Q[53] QB[53] bitcell
XB[52] BL BLB WL[52] VDD VSS Q[52] QB[52] bitcell
XB[51] BL BLB WL[51] VDD VSS Q[51] QB[51] bitcell
XB[50] BL BLB WL[50] VDD VSS Q[50] QB[50] bitcell
XB[49] BL BLB WL[49] VDD VSS Q[49] QB[49] bitcell
XB[48] BL BLB WL[48] VDD VSS Q[48] QB[48] bitcell
XB[47] BL BLB WL[47] VDD VSS Q[47] QB[47] bitcell
XB[46] BL BLB WL[46] VDD VSS Q[46] QB[46] bitcell
XB[45] BL BLB WL[45] VDD VSS Q[45] QB[45] bitcell
XB[44] BL BLB WL[44] VDD VSS Q[44] QB[44] bitcell
XB[43] BL BLB WL[43] VDD VSS Q[43] QB[43] bitcell
XB[42] BL BLB WL[42] VDD VSS Q[42] QB[42] bitcell
XB[41] BL BLB WL[41] VDD VSS Q[41] QB[41] bitcell
XB[40] BL BLB WL[40] VDD VSS Q[40] QB[40] bitcell
XB[39] BL BLB WL[39] VDD VSS Q[39] QB[39] bitcell
XB[38] BL BLB WL[38] VDD VSS Q[38] QB[38] bitcell
XB[37] BL BLB WL[37] VDD VSS Q[37] QB[37] bitcell
XB[36] BL BLB WL[36] VDD VSS Q[36] QB[36] bitcell
XB[35] BL BLB WL[35] VDD VSS Q[35] QB[35] bitcell
XB[34] BL BLB WL[34] VDD VSS Q[34] QB[34] bitcell
XB[33] BL BLB WL[33] VDD VSS Q[33] QB[33] bitcell
XB[32] BL BLB WL[32] VDD VSS Q[32] QB[32] bitcell
XB[31] BL BLB WL[31] VDD VSS Q[31] QB[31] bitcell
XB[30] BL BLB WL[30] VDD VSS Q[30] QB[30] bitcell
XB[29] BL BLB WL[29] VDD VSS Q[29] QB[29] bitcell
XB[28] BL BLB WL[28] VDD VSS Q[28] QB[28] bitcell
XB[27] BL BLB WL[27] VDD VSS Q[27] QB[27] bitcell
XB[26] BL BLB WL[26] VDD VSS Q[26] QB[26] bitcell
XB[25] BL BLB WL[25] VDD VSS Q[25] QB[25] bitcell
XB[24] BL BLB WL[24] VDD VSS Q[24] QB[24] bitcell
XB[23] BL BLB WL[23] VDD VSS Q[23] QB[23] bitcell
XB[22] BL BLB WL[22] VDD VSS Q[22] QB[22] bitcell
XB[21] BL BLB WL[21] VDD VSS Q[21] QB[21] bitcell
XB[20] BL BLB WL[20] VDD VSS Q[20] QB[20] bitcell
XB[19] BL BLB WL[19] VDD VSS Q[19] QB[19] bitcell
XB[18] BL BLB WL[18] VDD VSS Q[18] QB[18] bitcell
XB[17] BL BLB WL[17] VDD VSS Q[17] QB[17] bitcell
XB[16] BL BLB WL[16] VDD VSS Q[16] QB[16] bitcell
XB[15] BL BLB WL[15] VDD VSS Q[15] QB[15] bitcell
XB[14] BL BLB WL[14] VDD VSS Q[14] QB[14] bitcell
XB[13] BL BLB WL[13] VDD VSS Q[13] QB[13] bitcell
XB[12] BL BLB WL[12] VDD VSS Q[12] QB[12] bitcell
XB[11] BL BLB WL[11] VDD VSS Q[11] QB[11] bitcell
XB[10] BL BLB WL[10] VDD VSS Q[10] QB[10] bitcell
XB[9] BL BLB WL[9] VDD VSS Q[9] QB[9] bitcell
XB[8] BL BLB WL[8] VDD VSS Q[8] QB[8] bitcell
XB[7] BL BLB WL[7] VDD VSS Q[7] QB[7] bitcell
XB[6] BL BLB WL[6] VDD VSS Q[6] QB[6] bitcell
XB[5] BL BLB WL[5] VDD VSS Q[5] QB[5] bitcell
XB[4] BL BLB WL[4] VDD VSS Q[4] QB[4] bitcell
XB[3] BL BLB WL[3] VDD VSS Q[3] QB[3] bitcell
XB[2] BL BLB WL[2] VDD VSS Q[2] QB[2] bitcell
XB[1] BL BLB WL[1] VDD VSS Q[1] QB[1] bitcell
XB[0] BL BLB WL[0] VDD VSS Q[0] QB[0] bitcell
.ends

* expanding   symbol:  bitcell/bitcell.sym # of pins=7
** sym_path: design/bitcell/bitcell.sym
** sch_path: design/bitcell/bitcell.sch
.subckt bitcell BL BLB WL VDD VSS Q QB
*.iopin BL
*.iopin BLB
*.ipin WL
*.iopin VDD
*.iopin VSS
*.iopin Q
*.iopin QB
XMP0 Q QB VDD VDD sg13_lv_pmos w=0.15u l=0.13u ng=1 m=1
XMN0 Q QB VSS VSS sg13_lv_nmos w=0.30u l=0.13u ng=1 m=1
XMP1 QB Q VDD VDD sg13_lv_pmos w=0.15u l=0.13u ng=1 m=1
XMN1 QB Q VSS VSS sg13_lv_nmos w=0.30u l=0.13u ng=1 m=1
XMN2 BL WL Q VSS sg13_lv_nmos w=0.30u l=0.13u ng=1 m=1
XMN3 BLB WL QB VSS sg13_lv_nmos w=0.30u l=0.13u ng=1 m=1
**** begin user architecture code

* 6T SRAM bitcell, reference sizing from spec/bitcell-decision.md evidence 1

**** end user architecture code
.ends
