* I/O column read bench (circuit body for `klt sim`; no .control/.end).
*
* Two copies of design/column/column.spice (mux 2, 128 cells per bit line), column 0
* selected, one stored value each:
*   xa: selected cell (row r, column 0) holds 1; the other 127 rows of column 0 hold 0
*       (the data pattern that leaks the bit line which must stay high).
*       Half-selected cell (row r, column 1, WL high, mux off) holds 0; its other rows hold 1.
*   xb: every stored value inverted.
* Timeline (ns): bit lines start unbalanced; precharge/equalize 0.1..0.72; WL pulse 0.8..1.82
* (1 ns plateau); SAE rises at 1.2 and stays high. OUT/OUTB are read at 2.0, cell states at 2.8.
.include ../../design/bitcell/bitcell.spice
.include ../../design/column/precharge.spice
.include ../../design/column/column_mux.spice
.include ../../design/column/sense_amp.spice
.include ../../design/column/write_driver.spice
.include ../../design/column/column.spice

Vdd vdd 0 DC 1.2
Vpre preb 0 PULSE(1.2 0 0.1n 20p 20p 0.6n 100n)
Vwl  wl   0 PULSE(0 1.2 0.8n 20p 20p 1n 100n)
Vsae sae  0 PULSE(0 1.2 1.2n 20p 20p 10n 100n)
Vs0  sel0  0 DC 1.2
Vs0b sel0b 0 DC 0
Vs1  sel1  0 DC 0
Vs1b sel1b 0 DC 1.2
Vwlu wlu 0 DC 0
Vwe  we  0 DC 0
Vdin din 0 DC 0
*       PRE_B SEL0 SEL0B SEL1 SEL1B SAE WE DIN WL WLU DOUT DOUTB VDD VSS
Xa preb sel0 sel0b sel1 sel1b sae we din wl wlu oa oba vdd 0 column
Xb preb sel0 sel0b sel1 sel1b sae we din wl wlu ob obb vdd 0 column
* stored values: 1 = Q 0.9 / QB 0.3 (rail-independent, as sim/bitcell)
.ic v(xa.q0)=0.9 v(xa.qb0)=0.3 v(xa.uq0)=0.3 v(xa.uqb0)=0.9
.ic v(xa.q1)=0.3 v(xa.qb1)=0.9 v(xa.uq1)=0.9 v(xa.uqb1)=0.3
.ic v(xb.q0)=0.3 v(xb.qb0)=0.9 v(xb.uq0)=0.9 v(xb.uqb0)=0.3
.ic v(xb.q1)=0.9 v(xb.qb1)=0.3 v(xb.uq1)=0.3 v(xb.uqb1)=0.9
* bit lines start unbalanced so the equalize is exercised
.ic v(xa.bl0)=0.3 v(xa.blb0)=0.9 v(xa.bl1)=0.9 v(xa.blb1)=0.3
.ic v(xb.bl0)=0.3 v(xb.blb0)=0.9 v(xb.bl1)=0.9 v(xb.blb1)=0.3
