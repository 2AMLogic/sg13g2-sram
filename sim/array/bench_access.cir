* Access-time bench: clock edge to valid Q, and write completion (circuit body for `klt sim`;
* no .control/.end). GENERATED by `array_post.py gen-access` from the top-level instances of
* design/macro/macro.spice; run_array.sh fails if this file is stale.
*
* Representative macro: the real address latch, control, row decoder, data latch and out latch
* (full 32-bit banks), and the real bit slice 0 (2 bit-line pairs x 128 cells, precharge, mux,
* sense amp, write driver) at the selected address. The other 31 I/O are represented by their
* load only: 31 dummy slices (2 precharge, mux, sense amp, write driver on private bit lines)
* on PRE_B / SEL* / SAE / WE / DL[k] / DOUT[k], and 62 bitcells (their access gates) on the selected
* wordline WL[45]. Wordlines of other rows are not loaded: they do not switch at this address.
* Schematic level: no wire parasitics.
*
* Address 0x5A: A[7:1] = 45 selects WL[45], A[0] = 0 selects column 0 (SEL0 high).
* Six cycles, 8 ns period, CLK high 3 ns (rising 50 % at 4.05, 12.05, 20.05, 28.05, 36.05, 44.05 ns):
*   write 1, read (expects 1), write 0, read (expects 0), write 1, read (expects 1).
* The first read only puts a 1 into the output latch; the last read follows a read of 0, so its Q rise is
* a clean transition. CEN low, GWEN = WEN low in the write cycles; address, data and controls change in the
* CLK-low phase (latches transparent), 3 ns before each edge. Every cell starts holding 0 (.ic).
* All levels scale with VDD (request supply corner).
.include ../../design/macro/macro.spice

Vdd vdd 0 DC 1.2
* the macro's VSS port is a net named VSS, not node 0
Vvss VSS 0 DC 0
* thresholds that follow the supply corner
Bthr9 thr9 0 V = 0.9*v(vdd)
Bthr5 thr5 0 V = 0.5*v(vdd)
Bthr1 thr1 0 V = 0.1*v(vdd)
* clock: unit pulse x VDD
Vpclk pclk 0 PULSE(0 1 4n 100p 100p 3n 8n)
Bclk CLK 0 V = v(pclk)*v(vdd)
Bclkm clkm 0 V = v(CLK)
Bcen CEN 0 V = 0
* GWEN = WEN: low (write) in cycles 1 and 3, high (read) in cycles 2 and 4
Vpgw pgw 0 PWL(0 0 9n 0 9.1n 1 17n 1 17.1n 0 25n 0 25.1n 1 33n 1 33.1n 0 41n 0 41.1n 1 57n 1)
Bgwen GWEN 0 V = v(pgw)*v(vdd)
Bwen  WEN  0 V = v(pgw)*v(vdd)
* D[0]: 1 for the first write, 0 for the second
Vpd0 pd0 0 PWL(0 1 17n 1 17.1n 0 25n 0 25.1n 1 57n 1)
Bd0 D[0] 0 V = v(pd0)*v(vdd)
Bd1 D[1] 0 V = 0
Bd2 D[2] 0 V = 0
Bd3 D[3] 0 V = 0
Bd4 D[4] 0 V = 0
Bd5 D[5] 0 V = 0
Bd6 D[6] 0 V = 0
Bd7 D[7] 0 V = 0
Bd8 D[8] 0 V = 0
Bd9 D[9] 0 V = 0
Bd10 D[10] 0 V = 0
Bd11 D[11] 0 V = 0
Bd12 D[12] 0 V = 0
Bd13 D[13] 0 V = 0
Bd14 D[14] 0 V = 0
Bd15 D[15] 0 V = 0
Bd16 D[16] 0 V = 0
Bd17 D[17] 0 V = 0
Bd18 D[18] 0 V = 0
Bd19 D[19] 0 V = 0
Bd20 D[20] 0 V = 0
Bd21 D[21] 0 V = 0
Bd22 D[22] 0 V = 0
Bd23 D[23] 0 V = 0
Bd24 D[24] 0 V = 0
Bd25 D[25] 0 V = 0
Bd26 D[26] 0 V = 0
Bd27 D[27] 0 V = 0
Bd28 D[28] 0 V = 0
Bd29 D[29] 0 V = 0
Bd30 D[30] 0 V = 0
Bd31 D[31] 0 V = 0
Ba0 A[0] 0 V = 0
Ba1 A[1] 0 V = v(vdd)
Ba2 A[2] 0 V = 0
Ba3 A[3] 0 V = v(vdd)
Ba4 A[4] 0 V = v(vdd)
Ba5 A[5] 0 V = 0
Ba6 A[6] 0 V = v(vdd)
Ba7 A[7] 0 V = 0

* the macro, minus slices 1..31 (replaced by load below)
XAL CLK A[7] A[6] A[5] A[4] A[3] A[2] A[1] A[0] CEN GWEN WEN AL[7] AL[6] AL[5] AL[4] AL[3] AL[2] AL[1] AL[0] CENL GWENL WENL VDD
+ VSS addr_latch
XCTL CLK CENL GWENL WENL AL[0] PRE_B WLEN SAE WE SEL0 SEL0B SEL1 SEL1B VDD VSS control
XDEC AL[7] AL[6] AL[5] AL[4] AL[3] AL[2] AL[1] WLEN WL[127] WL[126] WL[125] WL[124] WL[123] WL[122] WL[121] WL[120] WL[119]
+ WL[118] WL[117] WL[116] WL[115] WL[114] WL[113] WL[112] WL[111] WL[110] WL[109] WL[108] WL[107] WL[106] WL[105] WL[104] WL[103]
+ WL[102] WL[101] WL[100] WL[99] WL[98] WL[97] WL[96] WL[95] WL[94] WL[93] WL[92] WL[91] WL[90] WL[89] WL[88] WL[87] WL[86] WL[85]
+ WL[84] WL[83] WL[82] WL[81] WL[80] WL[79] WL[78] WL[77] WL[76] WL[75] WL[74] WL[73] WL[72] WL[71] WL[70] WL[69] WL[68] WL[67]
+ WL[66] WL[65] WL[64] WL[63] WL[62] WL[61] WL[60] WL[59] WL[58] WL[57] WL[56] WL[55] WL[54] WL[53] WL[52] WL[51] WL[50] WL[49]
+ WL[48] WL[47] WL[46] WL[45] WL[44] WL[43] WL[42] WL[41] WL[40] WL[39] WL[38] WL[37] WL[36] WL[35] WL[34] WL[33] WL[32] WL[31]
+ WL[30] WL[29] WL[28] WL[27] WL[26] WL[25] WL[24] WL[23] WL[22] WL[21] WL[20] WL[19] WL[18] WL[17] WL[16] WL[15] WL[14] WL[13]
+ WL[12] WL[11] WL[10] WL[9] WL[8] WL[7] WL[6] WL[5] WL[4] WL[3] WL[2] WL[1] WL[0] VDD VSS row_decoder
XDL CLK D[31] D[30] D[29] D[28] D[27] D[26] D[25] D[24] D[23] D[22] D[21] D[20] D[19] D[18] D[17] D[16] D[15] D[14] D[13] D[12]
+ D[11] D[10] D[9] D[8] D[7] D[6] D[5] D[4] D[3] D[2] D[1] D[0] DL[31] DL[30] DL[29] DL[28] DL[27] DL[26] DL[25] DL[24] DL[23]
+ DL[22] DL[21] DL[20] DL[19] DL[18] DL[17] DL[16] DL[15] DL[14] DL[13] DL[12] DL[11] DL[10] DL[9] DL[8] DL[7] DL[6] DL[5] DL[4]
+ DL[3] DL[2] DL[1] DL[0] VDD VSS data_latch
XS[0] PRE_B SEL0 SEL0B SEL1 SEL1B SAE WE DL[0] WL[127] WL[126] WL[125] WL[124] WL[123] WL[122] WL[121] WL[120] WL[119] WL[118]
+ WL[117] WL[116] WL[115] WL[114] WL[113] WL[112] WL[111] WL[110] WL[109] WL[108] WL[107] WL[106] WL[105] WL[104] WL[103] WL[102]
+ WL[101] WL[100] WL[99] WL[98] WL[97] WL[96] WL[95] WL[94] WL[93] WL[92] WL[91] WL[90] WL[89] WL[88] WL[87] WL[86] WL[85] WL[84]
+ WL[83] WL[82] WL[81] WL[80] WL[79] WL[78] WL[77] WL[76] WL[75] WL[74] WL[73] WL[72] WL[71] WL[70] WL[69] WL[68] WL[67] WL[66]
+ WL[65] WL[64] WL[63] WL[62] WL[61] WL[60] WL[59] WL[58] WL[57] WL[56] WL[55] WL[54] WL[53] WL[52] WL[51] WL[50] WL[49] WL[48]
+ WL[47] WL[46] WL[45] WL[44] WL[43] WL[42] WL[41] WL[40] WL[39] WL[38] WL[37] WL[36] WL[35] WL[34] WL[33] WL[32] WL[31] WL[30]
+ WL[29] WL[28] WL[27] WL[26] WL[25] WL[24] WL[23] WL[22] WL[21] WL[20] WL[19] WL[18] WL[17] WL[16] WL[15] WL[14] WL[13] WL[12]
+ WL[11] WL[10] WL[9] WL[8] WL[7] WL[6] WL[5] WL[4] WL[3] WL[2] WL[1] WL[0] DOUT[0] DOUTB[0] VDD VSS bit_slice
XQL SAE DOUT[31] DOUT[30] DOUT[29] DOUT[28] DOUT[27] DOUT[26] DOUT[25] DOUT[24] DOUT[23] DOUT[22] DOUT[21] DOUT[20] DOUT[19]
+ DOUT[18] DOUT[17] DOUT[16] DOUT[15] DOUT[14] DOUT[13] DOUT[12] DOUT[11] DOUT[10] DOUT[9] DOUT[8] DOUT[7] DOUT[6] DOUT[5] DOUT[4]
+ DOUT[3] DOUT[2] DOUT[1] DOUT[0] Q[31] Q[30] Q[29] Q[28] Q[27] Q[26] Q[25] Q[24] Q[23] Q[22] Q[21] Q[20] Q[19] Q[18] Q[17] Q[16]
+ Q[15] Q[14] Q[13] Q[12] Q[11] Q[10] Q[9] Q[8] Q[7] Q[6] Q[5] Q[4] Q[3] Q[2] Q[1] Q[0] VDD VSS out_latch

* dummy wordline load: the access gates of the other 62 cells on the selected row
Xwl0 vdd vdd WL[45] vdd 0 dq0 dqb0 bitcell
Xwl1 vdd vdd WL[45] vdd 0 dq1 dqb1 bitcell
Xwl2 vdd vdd WL[45] vdd 0 dq2 dqb2 bitcell
Xwl3 vdd vdd WL[45] vdd 0 dq3 dqb3 bitcell
Xwl4 vdd vdd WL[45] vdd 0 dq4 dqb4 bitcell
Xwl5 vdd vdd WL[45] vdd 0 dq5 dqb5 bitcell
Xwl6 vdd vdd WL[45] vdd 0 dq6 dqb6 bitcell
Xwl7 vdd vdd WL[45] vdd 0 dq7 dqb7 bitcell
Xwl8 vdd vdd WL[45] vdd 0 dq8 dqb8 bitcell
Xwl9 vdd vdd WL[45] vdd 0 dq9 dqb9 bitcell
Xwl10 vdd vdd WL[45] vdd 0 dq10 dqb10 bitcell
Xwl11 vdd vdd WL[45] vdd 0 dq11 dqb11 bitcell
Xwl12 vdd vdd WL[45] vdd 0 dq12 dqb12 bitcell
Xwl13 vdd vdd WL[45] vdd 0 dq13 dqb13 bitcell
Xwl14 vdd vdd WL[45] vdd 0 dq14 dqb14 bitcell
Xwl15 vdd vdd WL[45] vdd 0 dq15 dqb15 bitcell
Xwl16 vdd vdd WL[45] vdd 0 dq16 dqb16 bitcell
Xwl17 vdd vdd WL[45] vdd 0 dq17 dqb17 bitcell
Xwl18 vdd vdd WL[45] vdd 0 dq18 dqb18 bitcell
Xwl19 vdd vdd WL[45] vdd 0 dq19 dqb19 bitcell
Xwl20 vdd vdd WL[45] vdd 0 dq20 dqb20 bitcell
Xwl21 vdd vdd WL[45] vdd 0 dq21 dqb21 bitcell
Xwl22 vdd vdd WL[45] vdd 0 dq22 dqb22 bitcell
Xwl23 vdd vdd WL[45] vdd 0 dq23 dqb23 bitcell
Xwl24 vdd vdd WL[45] vdd 0 dq24 dqb24 bitcell
Xwl25 vdd vdd WL[45] vdd 0 dq25 dqb25 bitcell
Xwl26 vdd vdd WL[45] vdd 0 dq26 dqb26 bitcell
Xwl27 vdd vdd WL[45] vdd 0 dq27 dqb27 bitcell
Xwl28 vdd vdd WL[45] vdd 0 dq28 dqb28 bitcell
Xwl29 vdd vdd WL[45] vdd 0 dq29 dqb29 bitcell
Xwl30 vdd vdd WL[45] vdd 0 dq30 dqb30 bitcell
Xwl31 vdd vdd WL[45] vdd 0 dq31 dqb31 bitcell
Xwl32 vdd vdd WL[45] vdd 0 dq32 dqb32 bitcell
Xwl33 vdd vdd WL[45] vdd 0 dq33 dqb33 bitcell
Xwl34 vdd vdd WL[45] vdd 0 dq34 dqb34 bitcell
Xwl35 vdd vdd WL[45] vdd 0 dq35 dqb35 bitcell
Xwl36 vdd vdd WL[45] vdd 0 dq36 dqb36 bitcell
Xwl37 vdd vdd WL[45] vdd 0 dq37 dqb37 bitcell
Xwl38 vdd vdd WL[45] vdd 0 dq38 dqb38 bitcell
Xwl39 vdd vdd WL[45] vdd 0 dq39 dqb39 bitcell
Xwl40 vdd vdd WL[45] vdd 0 dq40 dqb40 bitcell
Xwl41 vdd vdd WL[45] vdd 0 dq41 dqb41 bitcell
Xwl42 vdd vdd WL[45] vdd 0 dq42 dqb42 bitcell
Xwl43 vdd vdd WL[45] vdd 0 dq43 dqb43 bitcell
Xwl44 vdd vdd WL[45] vdd 0 dq44 dqb44 bitcell
Xwl45 vdd vdd WL[45] vdd 0 dq45 dqb45 bitcell
Xwl46 vdd vdd WL[45] vdd 0 dq46 dqb46 bitcell
Xwl47 vdd vdd WL[45] vdd 0 dq47 dqb47 bitcell
Xwl48 vdd vdd WL[45] vdd 0 dq48 dqb48 bitcell
Xwl49 vdd vdd WL[45] vdd 0 dq49 dqb49 bitcell
Xwl50 vdd vdd WL[45] vdd 0 dq50 dqb50 bitcell
Xwl51 vdd vdd WL[45] vdd 0 dq51 dqb51 bitcell
Xwl52 vdd vdd WL[45] vdd 0 dq52 dqb52 bitcell
Xwl53 vdd vdd WL[45] vdd 0 dq53 dqb53 bitcell
Xwl54 vdd vdd WL[45] vdd 0 dq54 dqb54 bitcell
Xwl55 vdd vdd WL[45] vdd 0 dq55 dqb55 bitcell
Xwl56 vdd vdd WL[45] vdd 0 dq56 dqb56 bitcell
Xwl57 vdd vdd WL[45] vdd 0 dq57 dqb57 bitcell
Xwl58 vdd vdd WL[45] vdd 0 dq58 dqb58 bitcell
Xwl59 vdd vdd WL[45] vdd 0 dq59 dqb59 bitcell
Xwl60 vdd vdd WL[45] vdd 0 dq60 dqb60 bitcell
Xwl61 vdd vdd WL[45] vdd 0 dq61 dqb61 bitcell

* dummy slices: control and data fan-out of I/O 1..31 (bit lines private, otherwise floating)
Xfp0_1 PRE_B fb0_1 fbb0_1 vdd 0 precharge
Xfp1_1 PRE_B fb1_1 fbb1_1 vdd 0 precharge
Xfm_1 SEL0 SEL0B SEL1 SEL1B fb0_1 fbb0_1 fb1_1 fbb1_1 fbm_1 fbbm_1 vdd 0 column_mux
Xfs_1 SAE fbm_1 fbbm_1 DOUT[1] fdoutb_1 vdd 0 sense_amp
Xfw_1 WE DL[1] fbm_1 fbbm_1 vdd 0 write_driver
Xfp0_2 PRE_B fb0_2 fbb0_2 vdd 0 precharge
Xfp1_2 PRE_B fb1_2 fbb1_2 vdd 0 precharge
Xfm_2 SEL0 SEL0B SEL1 SEL1B fb0_2 fbb0_2 fb1_2 fbb1_2 fbm_2 fbbm_2 vdd 0 column_mux
Xfs_2 SAE fbm_2 fbbm_2 DOUT[2] fdoutb_2 vdd 0 sense_amp
Xfw_2 WE DL[2] fbm_2 fbbm_2 vdd 0 write_driver
Xfp0_3 PRE_B fb0_3 fbb0_3 vdd 0 precharge
Xfp1_3 PRE_B fb1_3 fbb1_3 vdd 0 precharge
Xfm_3 SEL0 SEL0B SEL1 SEL1B fb0_3 fbb0_3 fb1_3 fbb1_3 fbm_3 fbbm_3 vdd 0 column_mux
Xfs_3 SAE fbm_3 fbbm_3 DOUT[3] fdoutb_3 vdd 0 sense_amp
Xfw_3 WE DL[3] fbm_3 fbbm_3 vdd 0 write_driver
Xfp0_4 PRE_B fb0_4 fbb0_4 vdd 0 precharge
Xfp1_4 PRE_B fb1_4 fbb1_4 vdd 0 precharge
Xfm_4 SEL0 SEL0B SEL1 SEL1B fb0_4 fbb0_4 fb1_4 fbb1_4 fbm_4 fbbm_4 vdd 0 column_mux
Xfs_4 SAE fbm_4 fbbm_4 DOUT[4] fdoutb_4 vdd 0 sense_amp
Xfw_4 WE DL[4] fbm_4 fbbm_4 vdd 0 write_driver
Xfp0_5 PRE_B fb0_5 fbb0_5 vdd 0 precharge
Xfp1_5 PRE_B fb1_5 fbb1_5 vdd 0 precharge
Xfm_5 SEL0 SEL0B SEL1 SEL1B fb0_5 fbb0_5 fb1_5 fbb1_5 fbm_5 fbbm_5 vdd 0 column_mux
Xfs_5 SAE fbm_5 fbbm_5 DOUT[5] fdoutb_5 vdd 0 sense_amp
Xfw_5 WE DL[5] fbm_5 fbbm_5 vdd 0 write_driver
Xfp0_6 PRE_B fb0_6 fbb0_6 vdd 0 precharge
Xfp1_6 PRE_B fb1_6 fbb1_6 vdd 0 precharge
Xfm_6 SEL0 SEL0B SEL1 SEL1B fb0_6 fbb0_6 fb1_6 fbb1_6 fbm_6 fbbm_6 vdd 0 column_mux
Xfs_6 SAE fbm_6 fbbm_6 DOUT[6] fdoutb_6 vdd 0 sense_amp
Xfw_6 WE DL[6] fbm_6 fbbm_6 vdd 0 write_driver
Xfp0_7 PRE_B fb0_7 fbb0_7 vdd 0 precharge
Xfp1_7 PRE_B fb1_7 fbb1_7 vdd 0 precharge
Xfm_7 SEL0 SEL0B SEL1 SEL1B fb0_7 fbb0_7 fb1_7 fbb1_7 fbm_7 fbbm_7 vdd 0 column_mux
Xfs_7 SAE fbm_7 fbbm_7 DOUT[7] fdoutb_7 vdd 0 sense_amp
Xfw_7 WE DL[7] fbm_7 fbbm_7 vdd 0 write_driver
Xfp0_8 PRE_B fb0_8 fbb0_8 vdd 0 precharge
Xfp1_8 PRE_B fb1_8 fbb1_8 vdd 0 precharge
Xfm_8 SEL0 SEL0B SEL1 SEL1B fb0_8 fbb0_8 fb1_8 fbb1_8 fbm_8 fbbm_8 vdd 0 column_mux
Xfs_8 SAE fbm_8 fbbm_8 DOUT[8] fdoutb_8 vdd 0 sense_amp
Xfw_8 WE DL[8] fbm_8 fbbm_8 vdd 0 write_driver
Xfp0_9 PRE_B fb0_9 fbb0_9 vdd 0 precharge
Xfp1_9 PRE_B fb1_9 fbb1_9 vdd 0 precharge
Xfm_9 SEL0 SEL0B SEL1 SEL1B fb0_9 fbb0_9 fb1_9 fbb1_9 fbm_9 fbbm_9 vdd 0 column_mux
Xfs_9 SAE fbm_9 fbbm_9 DOUT[9] fdoutb_9 vdd 0 sense_amp
Xfw_9 WE DL[9] fbm_9 fbbm_9 vdd 0 write_driver
Xfp0_10 PRE_B fb0_10 fbb0_10 vdd 0 precharge
Xfp1_10 PRE_B fb1_10 fbb1_10 vdd 0 precharge
Xfm_10 SEL0 SEL0B SEL1 SEL1B fb0_10 fbb0_10 fb1_10 fbb1_10 fbm_10 fbbm_10 vdd 0 column_mux
Xfs_10 SAE fbm_10 fbbm_10 DOUT[10] fdoutb_10 vdd 0 sense_amp
Xfw_10 WE DL[10] fbm_10 fbbm_10 vdd 0 write_driver
Xfp0_11 PRE_B fb0_11 fbb0_11 vdd 0 precharge
Xfp1_11 PRE_B fb1_11 fbb1_11 vdd 0 precharge
Xfm_11 SEL0 SEL0B SEL1 SEL1B fb0_11 fbb0_11 fb1_11 fbb1_11 fbm_11 fbbm_11 vdd 0 column_mux
Xfs_11 SAE fbm_11 fbbm_11 DOUT[11] fdoutb_11 vdd 0 sense_amp
Xfw_11 WE DL[11] fbm_11 fbbm_11 vdd 0 write_driver
Xfp0_12 PRE_B fb0_12 fbb0_12 vdd 0 precharge
Xfp1_12 PRE_B fb1_12 fbb1_12 vdd 0 precharge
Xfm_12 SEL0 SEL0B SEL1 SEL1B fb0_12 fbb0_12 fb1_12 fbb1_12 fbm_12 fbbm_12 vdd 0 column_mux
Xfs_12 SAE fbm_12 fbbm_12 DOUT[12] fdoutb_12 vdd 0 sense_amp
Xfw_12 WE DL[12] fbm_12 fbbm_12 vdd 0 write_driver
Xfp0_13 PRE_B fb0_13 fbb0_13 vdd 0 precharge
Xfp1_13 PRE_B fb1_13 fbb1_13 vdd 0 precharge
Xfm_13 SEL0 SEL0B SEL1 SEL1B fb0_13 fbb0_13 fb1_13 fbb1_13 fbm_13 fbbm_13 vdd 0 column_mux
Xfs_13 SAE fbm_13 fbbm_13 DOUT[13] fdoutb_13 vdd 0 sense_amp
Xfw_13 WE DL[13] fbm_13 fbbm_13 vdd 0 write_driver
Xfp0_14 PRE_B fb0_14 fbb0_14 vdd 0 precharge
Xfp1_14 PRE_B fb1_14 fbb1_14 vdd 0 precharge
Xfm_14 SEL0 SEL0B SEL1 SEL1B fb0_14 fbb0_14 fb1_14 fbb1_14 fbm_14 fbbm_14 vdd 0 column_mux
Xfs_14 SAE fbm_14 fbbm_14 DOUT[14] fdoutb_14 vdd 0 sense_amp
Xfw_14 WE DL[14] fbm_14 fbbm_14 vdd 0 write_driver
Xfp0_15 PRE_B fb0_15 fbb0_15 vdd 0 precharge
Xfp1_15 PRE_B fb1_15 fbb1_15 vdd 0 precharge
Xfm_15 SEL0 SEL0B SEL1 SEL1B fb0_15 fbb0_15 fb1_15 fbb1_15 fbm_15 fbbm_15 vdd 0 column_mux
Xfs_15 SAE fbm_15 fbbm_15 DOUT[15] fdoutb_15 vdd 0 sense_amp
Xfw_15 WE DL[15] fbm_15 fbbm_15 vdd 0 write_driver
Xfp0_16 PRE_B fb0_16 fbb0_16 vdd 0 precharge
Xfp1_16 PRE_B fb1_16 fbb1_16 vdd 0 precharge
Xfm_16 SEL0 SEL0B SEL1 SEL1B fb0_16 fbb0_16 fb1_16 fbb1_16 fbm_16 fbbm_16 vdd 0 column_mux
Xfs_16 SAE fbm_16 fbbm_16 DOUT[16] fdoutb_16 vdd 0 sense_amp
Xfw_16 WE DL[16] fbm_16 fbbm_16 vdd 0 write_driver
Xfp0_17 PRE_B fb0_17 fbb0_17 vdd 0 precharge
Xfp1_17 PRE_B fb1_17 fbb1_17 vdd 0 precharge
Xfm_17 SEL0 SEL0B SEL1 SEL1B fb0_17 fbb0_17 fb1_17 fbb1_17 fbm_17 fbbm_17 vdd 0 column_mux
Xfs_17 SAE fbm_17 fbbm_17 DOUT[17] fdoutb_17 vdd 0 sense_amp
Xfw_17 WE DL[17] fbm_17 fbbm_17 vdd 0 write_driver
Xfp0_18 PRE_B fb0_18 fbb0_18 vdd 0 precharge
Xfp1_18 PRE_B fb1_18 fbb1_18 vdd 0 precharge
Xfm_18 SEL0 SEL0B SEL1 SEL1B fb0_18 fbb0_18 fb1_18 fbb1_18 fbm_18 fbbm_18 vdd 0 column_mux
Xfs_18 SAE fbm_18 fbbm_18 DOUT[18] fdoutb_18 vdd 0 sense_amp
Xfw_18 WE DL[18] fbm_18 fbbm_18 vdd 0 write_driver
Xfp0_19 PRE_B fb0_19 fbb0_19 vdd 0 precharge
Xfp1_19 PRE_B fb1_19 fbb1_19 vdd 0 precharge
Xfm_19 SEL0 SEL0B SEL1 SEL1B fb0_19 fbb0_19 fb1_19 fbb1_19 fbm_19 fbbm_19 vdd 0 column_mux
Xfs_19 SAE fbm_19 fbbm_19 DOUT[19] fdoutb_19 vdd 0 sense_amp
Xfw_19 WE DL[19] fbm_19 fbbm_19 vdd 0 write_driver
Xfp0_20 PRE_B fb0_20 fbb0_20 vdd 0 precharge
Xfp1_20 PRE_B fb1_20 fbb1_20 vdd 0 precharge
Xfm_20 SEL0 SEL0B SEL1 SEL1B fb0_20 fbb0_20 fb1_20 fbb1_20 fbm_20 fbbm_20 vdd 0 column_mux
Xfs_20 SAE fbm_20 fbbm_20 DOUT[20] fdoutb_20 vdd 0 sense_amp
Xfw_20 WE DL[20] fbm_20 fbbm_20 vdd 0 write_driver
Xfp0_21 PRE_B fb0_21 fbb0_21 vdd 0 precharge
Xfp1_21 PRE_B fb1_21 fbb1_21 vdd 0 precharge
Xfm_21 SEL0 SEL0B SEL1 SEL1B fb0_21 fbb0_21 fb1_21 fbb1_21 fbm_21 fbbm_21 vdd 0 column_mux
Xfs_21 SAE fbm_21 fbbm_21 DOUT[21] fdoutb_21 vdd 0 sense_amp
Xfw_21 WE DL[21] fbm_21 fbbm_21 vdd 0 write_driver
Xfp0_22 PRE_B fb0_22 fbb0_22 vdd 0 precharge
Xfp1_22 PRE_B fb1_22 fbb1_22 vdd 0 precharge
Xfm_22 SEL0 SEL0B SEL1 SEL1B fb0_22 fbb0_22 fb1_22 fbb1_22 fbm_22 fbbm_22 vdd 0 column_mux
Xfs_22 SAE fbm_22 fbbm_22 DOUT[22] fdoutb_22 vdd 0 sense_amp
Xfw_22 WE DL[22] fbm_22 fbbm_22 vdd 0 write_driver
Xfp0_23 PRE_B fb0_23 fbb0_23 vdd 0 precharge
Xfp1_23 PRE_B fb1_23 fbb1_23 vdd 0 precharge
Xfm_23 SEL0 SEL0B SEL1 SEL1B fb0_23 fbb0_23 fb1_23 fbb1_23 fbm_23 fbbm_23 vdd 0 column_mux
Xfs_23 SAE fbm_23 fbbm_23 DOUT[23] fdoutb_23 vdd 0 sense_amp
Xfw_23 WE DL[23] fbm_23 fbbm_23 vdd 0 write_driver
Xfp0_24 PRE_B fb0_24 fbb0_24 vdd 0 precharge
Xfp1_24 PRE_B fb1_24 fbb1_24 vdd 0 precharge
Xfm_24 SEL0 SEL0B SEL1 SEL1B fb0_24 fbb0_24 fb1_24 fbb1_24 fbm_24 fbbm_24 vdd 0 column_mux
Xfs_24 SAE fbm_24 fbbm_24 DOUT[24] fdoutb_24 vdd 0 sense_amp
Xfw_24 WE DL[24] fbm_24 fbbm_24 vdd 0 write_driver
Xfp0_25 PRE_B fb0_25 fbb0_25 vdd 0 precharge
Xfp1_25 PRE_B fb1_25 fbb1_25 vdd 0 precharge
Xfm_25 SEL0 SEL0B SEL1 SEL1B fb0_25 fbb0_25 fb1_25 fbb1_25 fbm_25 fbbm_25 vdd 0 column_mux
Xfs_25 SAE fbm_25 fbbm_25 DOUT[25] fdoutb_25 vdd 0 sense_amp
Xfw_25 WE DL[25] fbm_25 fbbm_25 vdd 0 write_driver
Xfp0_26 PRE_B fb0_26 fbb0_26 vdd 0 precharge
Xfp1_26 PRE_B fb1_26 fbb1_26 vdd 0 precharge
Xfm_26 SEL0 SEL0B SEL1 SEL1B fb0_26 fbb0_26 fb1_26 fbb1_26 fbm_26 fbbm_26 vdd 0 column_mux
Xfs_26 SAE fbm_26 fbbm_26 DOUT[26] fdoutb_26 vdd 0 sense_amp
Xfw_26 WE DL[26] fbm_26 fbbm_26 vdd 0 write_driver
Xfp0_27 PRE_B fb0_27 fbb0_27 vdd 0 precharge
Xfp1_27 PRE_B fb1_27 fbb1_27 vdd 0 precharge
Xfm_27 SEL0 SEL0B SEL1 SEL1B fb0_27 fbb0_27 fb1_27 fbb1_27 fbm_27 fbbm_27 vdd 0 column_mux
Xfs_27 SAE fbm_27 fbbm_27 DOUT[27] fdoutb_27 vdd 0 sense_amp
Xfw_27 WE DL[27] fbm_27 fbbm_27 vdd 0 write_driver
Xfp0_28 PRE_B fb0_28 fbb0_28 vdd 0 precharge
Xfp1_28 PRE_B fb1_28 fbb1_28 vdd 0 precharge
Xfm_28 SEL0 SEL0B SEL1 SEL1B fb0_28 fbb0_28 fb1_28 fbb1_28 fbm_28 fbbm_28 vdd 0 column_mux
Xfs_28 SAE fbm_28 fbbm_28 DOUT[28] fdoutb_28 vdd 0 sense_amp
Xfw_28 WE DL[28] fbm_28 fbbm_28 vdd 0 write_driver
Xfp0_29 PRE_B fb0_29 fbb0_29 vdd 0 precharge
Xfp1_29 PRE_B fb1_29 fbb1_29 vdd 0 precharge
Xfm_29 SEL0 SEL0B SEL1 SEL1B fb0_29 fbb0_29 fb1_29 fbb1_29 fbm_29 fbbm_29 vdd 0 column_mux
Xfs_29 SAE fbm_29 fbbm_29 DOUT[29] fdoutb_29 vdd 0 sense_amp
Xfw_29 WE DL[29] fbm_29 fbbm_29 vdd 0 write_driver
Xfp0_30 PRE_B fb0_30 fbb0_30 vdd 0 precharge
Xfp1_30 PRE_B fb1_30 fbb1_30 vdd 0 precharge
Xfm_30 SEL0 SEL0B SEL1 SEL1B fb0_30 fbb0_30 fb1_30 fbb1_30 fbm_30 fbbm_30 vdd 0 column_mux
Xfs_30 SAE fbm_30 fbbm_30 DOUT[30] fdoutb_30 vdd 0 sense_amp
Xfw_30 WE DL[30] fbm_30 fbbm_30 vdd 0 write_driver
Xfp0_31 PRE_B fb0_31 fbb0_31 vdd 0 precharge
Xfp1_31 PRE_B fb1_31 fbb1_31 vdd 0 precharge
Xfm_31 SEL0 SEL0B SEL1 SEL1B fb0_31 fbb0_31 fb1_31 fbb1_31 fbm_31 fbbm_31 vdd 0 column_mux
Xfs_31 SAE fbm_31 fbbm_31 DOUT[31] fdoutb_31 vdd 0 sense_amp
Xfw_31 WE DL[31] fbm_31 fbbm_31 vdd 0 write_driver

* monitors (VCVS, no load) for nets the .meas lines cannot index directly
Eq0 q0m 0 Q[0] 0 1
Ewl wl45m 0 WL[45] 0 1
Ecq cq 0 xs[0].xa0.q[45] 0 1
Ecqb cqb 0 xs[0].xa0.qb[45] 0 1
* every cell starts holding 0 (rail-independent levels, as sim/bitcell): no metastable start for the
* operating point. The selected cell is one of them; the first write puts a 1 into it.
.ic v(xs[0].xa0.q[0])=0.3 v(xs[0].xa0.qb[0])=0.9
.ic v(xs[0].xa0.q[1])=0.3 v(xs[0].xa0.qb[1])=0.9
.ic v(xs[0].xa0.q[2])=0.3 v(xs[0].xa0.qb[2])=0.9
.ic v(xs[0].xa0.q[3])=0.3 v(xs[0].xa0.qb[3])=0.9
.ic v(xs[0].xa0.q[4])=0.3 v(xs[0].xa0.qb[4])=0.9
.ic v(xs[0].xa0.q[5])=0.3 v(xs[0].xa0.qb[5])=0.9
.ic v(xs[0].xa0.q[6])=0.3 v(xs[0].xa0.qb[6])=0.9
.ic v(xs[0].xa0.q[7])=0.3 v(xs[0].xa0.qb[7])=0.9
.ic v(xs[0].xa0.q[8])=0.3 v(xs[0].xa0.qb[8])=0.9
.ic v(xs[0].xa0.q[9])=0.3 v(xs[0].xa0.qb[9])=0.9
.ic v(xs[0].xa0.q[10])=0.3 v(xs[0].xa0.qb[10])=0.9
.ic v(xs[0].xa0.q[11])=0.3 v(xs[0].xa0.qb[11])=0.9
.ic v(xs[0].xa0.q[12])=0.3 v(xs[0].xa0.qb[12])=0.9
.ic v(xs[0].xa0.q[13])=0.3 v(xs[0].xa0.qb[13])=0.9
.ic v(xs[0].xa0.q[14])=0.3 v(xs[0].xa0.qb[14])=0.9
.ic v(xs[0].xa0.q[15])=0.3 v(xs[0].xa0.qb[15])=0.9
.ic v(xs[0].xa0.q[16])=0.3 v(xs[0].xa0.qb[16])=0.9
.ic v(xs[0].xa0.q[17])=0.3 v(xs[0].xa0.qb[17])=0.9
.ic v(xs[0].xa0.q[18])=0.3 v(xs[0].xa0.qb[18])=0.9
.ic v(xs[0].xa0.q[19])=0.3 v(xs[0].xa0.qb[19])=0.9
.ic v(xs[0].xa0.q[20])=0.3 v(xs[0].xa0.qb[20])=0.9
.ic v(xs[0].xa0.q[21])=0.3 v(xs[0].xa0.qb[21])=0.9
.ic v(xs[0].xa0.q[22])=0.3 v(xs[0].xa0.qb[22])=0.9
.ic v(xs[0].xa0.q[23])=0.3 v(xs[0].xa0.qb[23])=0.9
.ic v(xs[0].xa0.q[24])=0.3 v(xs[0].xa0.qb[24])=0.9
.ic v(xs[0].xa0.q[25])=0.3 v(xs[0].xa0.qb[25])=0.9
.ic v(xs[0].xa0.q[26])=0.3 v(xs[0].xa0.qb[26])=0.9
.ic v(xs[0].xa0.q[27])=0.3 v(xs[0].xa0.qb[27])=0.9
.ic v(xs[0].xa0.q[28])=0.3 v(xs[0].xa0.qb[28])=0.9
.ic v(xs[0].xa0.q[29])=0.3 v(xs[0].xa0.qb[29])=0.9
.ic v(xs[0].xa0.q[30])=0.3 v(xs[0].xa0.qb[30])=0.9
.ic v(xs[0].xa0.q[31])=0.3 v(xs[0].xa0.qb[31])=0.9
.ic v(xs[0].xa0.q[32])=0.3 v(xs[0].xa0.qb[32])=0.9
.ic v(xs[0].xa0.q[33])=0.3 v(xs[0].xa0.qb[33])=0.9
.ic v(xs[0].xa0.q[34])=0.3 v(xs[0].xa0.qb[34])=0.9
.ic v(xs[0].xa0.q[35])=0.3 v(xs[0].xa0.qb[35])=0.9
.ic v(xs[0].xa0.q[36])=0.3 v(xs[0].xa0.qb[36])=0.9
.ic v(xs[0].xa0.q[37])=0.3 v(xs[0].xa0.qb[37])=0.9
.ic v(xs[0].xa0.q[38])=0.3 v(xs[0].xa0.qb[38])=0.9
.ic v(xs[0].xa0.q[39])=0.3 v(xs[0].xa0.qb[39])=0.9
.ic v(xs[0].xa0.q[40])=0.3 v(xs[0].xa0.qb[40])=0.9
.ic v(xs[0].xa0.q[41])=0.3 v(xs[0].xa0.qb[41])=0.9
.ic v(xs[0].xa0.q[42])=0.3 v(xs[0].xa0.qb[42])=0.9
.ic v(xs[0].xa0.q[43])=0.3 v(xs[0].xa0.qb[43])=0.9
.ic v(xs[0].xa0.q[44])=0.3 v(xs[0].xa0.qb[44])=0.9
.ic v(xs[0].xa0.q[45])=0.3 v(xs[0].xa0.qb[45])=0.9
.ic v(xs[0].xa0.q[46])=0.3 v(xs[0].xa0.qb[46])=0.9
.ic v(xs[0].xa0.q[47])=0.3 v(xs[0].xa0.qb[47])=0.9
.ic v(xs[0].xa0.q[48])=0.3 v(xs[0].xa0.qb[48])=0.9
.ic v(xs[0].xa0.q[49])=0.3 v(xs[0].xa0.qb[49])=0.9
.ic v(xs[0].xa0.q[50])=0.3 v(xs[0].xa0.qb[50])=0.9
.ic v(xs[0].xa0.q[51])=0.3 v(xs[0].xa0.qb[51])=0.9
.ic v(xs[0].xa0.q[52])=0.3 v(xs[0].xa0.qb[52])=0.9
.ic v(xs[0].xa0.q[53])=0.3 v(xs[0].xa0.qb[53])=0.9
.ic v(xs[0].xa0.q[54])=0.3 v(xs[0].xa0.qb[54])=0.9
.ic v(xs[0].xa0.q[55])=0.3 v(xs[0].xa0.qb[55])=0.9
.ic v(xs[0].xa0.q[56])=0.3 v(xs[0].xa0.qb[56])=0.9
.ic v(xs[0].xa0.q[57])=0.3 v(xs[0].xa0.qb[57])=0.9
.ic v(xs[0].xa0.q[58])=0.3 v(xs[0].xa0.qb[58])=0.9
.ic v(xs[0].xa0.q[59])=0.3 v(xs[0].xa0.qb[59])=0.9
.ic v(xs[0].xa0.q[60])=0.3 v(xs[0].xa0.qb[60])=0.9
.ic v(xs[0].xa0.q[61])=0.3 v(xs[0].xa0.qb[61])=0.9
.ic v(xs[0].xa0.q[62])=0.3 v(xs[0].xa0.qb[62])=0.9
.ic v(xs[0].xa0.q[63])=0.3 v(xs[0].xa0.qb[63])=0.9
.ic v(xs[0].xa0.q[64])=0.3 v(xs[0].xa0.qb[64])=0.9
.ic v(xs[0].xa0.q[65])=0.3 v(xs[0].xa0.qb[65])=0.9
.ic v(xs[0].xa0.q[66])=0.3 v(xs[0].xa0.qb[66])=0.9
.ic v(xs[0].xa0.q[67])=0.3 v(xs[0].xa0.qb[67])=0.9
.ic v(xs[0].xa0.q[68])=0.3 v(xs[0].xa0.qb[68])=0.9
.ic v(xs[0].xa0.q[69])=0.3 v(xs[0].xa0.qb[69])=0.9
.ic v(xs[0].xa0.q[70])=0.3 v(xs[0].xa0.qb[70])=0.9
.ic v(xs[0].xa0.q[71])=0.3 v(xs[0].xa0.qb[71])=0.9
.ic v(xs[0].xa0.q[72])=0.3 v(xs[0].xa0.qb[72])=0.9
.ic v(xs[0].xa0.q[73])=0.3 v(xs[0].xa0.qb[73])=0.9
.ic v(xs[0].xa0.q[74])=0.3 v(xs[0].xa0.qb[74])=0.9
.ic v(xs[0].xa0.q[75])=0.3 v(xs[0].xa0.qb[75])=0.9
.ic v(xs[0].xa0.q[76])=0.3 v(xs[0].xa0.qb[76])=0.9
.ic v(xs[0].xa0.q[77])=0.3 v(xs[0].xa0.qb[77])=0.9
.ic v(xs[0].xa0.q[78])=0.3 v(xs[0].xa0.qb[78])=0.9
.ic v(xs[0].xa0.q[79])=0.3 v(xs[0].xa0.qb[79])=0.9
.ic v(xs[0].xa0.q[80])=0.3 v(xs[0].xa0.qb[80])=0.9
.ic v(xs[0].xa0.q[81])=0.3 v(xs[0].xa0.qb[81])=0.9
.ic v(xs[0].xa0.q[82])=0.3 v(xs[0].xa0.qb[82])=0.9
.ic v(xs[0].xa0.q[83])=0.3 v(xs[0].xa0.qb[83])=0.9
.ic v(xs[0].xa0.q[84])=0.3 v(xs[0].xa0.qb[84])=0.9
.ic v(xs[0].xa0.q[85])=0.3 v(xs[0].xa0.qb[85])=0.9
.ic v(xs[0].xa0.q[86])=0.3 v(xs[0].xa0.qb[86])=0.9
.ic v(xs[0].xa0.q[87])=0.3 v(xs[0].xa0.qb[87])=0.9
.ic v(xs[0].xa0.q[88])=0.3 v(xs[0].xa0.qb[88])=0.9
.ic v(xs[0].xa0.q[89])=0.3 v(xs[0].xa0.qb[89])=0.9
.ic v(xs[0].xa0.q[90])=0.3 v(xs[0].xa0.qb[90])=0.9
.ic v(xs[0].xa0.q[91])=0.3 v(xs[0].xa0.qb[91])=0.9
.ic v(xs[0].xa0.q[92])=0.3 v(xs[0].xa0.qb[92])=0.9
.ic v(xs[0].xa0.q[93])=0.3 v(xs[0].xa0.qb[93])=0.9
.ic v(xs[0].xa0.q[94])=0.3 v(xs[0].xa0.qb[94])=0.9
.ic v(xs[0].xa0.q[95])=0.3 v(xs[0].xa0.qb[95])=0.9
.ic v(xs[0].xa0.q[96])=0.3 v(xs[0].xa0.qb[96])=0.9
.ic v(xs[0].xa0.q[97])=0.3 v(xs[0].xa0.qb[97])=0.9
.ic v(xs[0].xa0.q[98])=0.3 v(xs[0].xa0.qb[98])=0.9
.ic v(xs[0].xa0.q[99])=0.3 v(xs[0].xa0.qb[99])=0.9
.ic v(xs[0].xa0.q[100])=0.3 v(xs[0].xa0.qb[100])=0.9
.ic v(xs[0].xa0.q[101])=0.3 v(xs[0].xa0.qb[101])=0.9
.ic v(xs[0].xa0.q[102])=0.3 v(xs[0].xa0.qb[102])=0.9
.ic v(xs[0].xa0.q[103])=0.3 v(xs[0].xa0.qb[103])=0.9
.ic v(xs[0].xa0.q[104])=0.3 v(xs[0].xa0.qb[104])=0.9
.ic v(xs[0].xa0.q[105])=0.3 v(xs[0].xa0.qb[105])=0.9
.ic v(xs[0].xa0.q[106])=0.3 v(xs[0].xa0.qb[106])=0.9
.ic v(xs[0].xa0.q[107])=0.3 v(xs[0].xa0.qb[107])=0.9
.ic v(xs[0].xa0.q[108])=0.3 v(xs[0].xa0.qb[108])=0.9
.ic v(xs[0].xa0.q[109])=0.3 v(xs[0].xa0.qb[109])=0.9
.ic v(xs[0].xa0.q[110])=0.3 v(xs[0].xa0.qb[110])=0.9
.ic v(xs[0].xa0.q[111])=0.3 v(xs[0].xa0.qb[111])=0.9
.ic v(xs[0].xa0.q[112])=0.3 v(xs[0].xa0.qb[112])=0.9
.ic v(xs[0].xa0.q[113])=0.3 v(xs[0].xa0.qb[113])=0.9
.ic v(xs[0].xa0.q[114])=0.3 v(xs[0].xa0.qb[114])=0.9
.ic v(xs[0].xa0.q[115])=0.3 v(xs[0].xa0.qb[115])=0.9
.ic v(xs[0].xa0.q[116])=0.3 v(xs[0].xa0.qb[116])=0.9
.ic v(xs[0].xa0.q[117])=0.3 v(xs[0].xa0.qb[117])=0.9
.ic v(xs[0].xa0.q[118])=0.3 v(xs[0].xa0.qb[118])=0.9
.ic v(xs[0].xa0.q[119])=0.3 v(xs[0].xa0.qb[119])=0.9
.ic v(xs[0].xa0.q[120])=0.3 v(xs[0].xa0.qb[120])=0.9
.ic v(xs[0].xa0.q[121])=0.3 v(xs[0].xa0.qb[121])=0.9
.ic v(xs[0].xa0.q[122])=0.3 v(xs[0].xa0.qb[122])=0.9
.ic v(xs[0].xa0.q[123])=0.3 v(xs[0].xa0.qb[123])=0.9
.ic v(xs[0].xa0.q[124])=0.3 v(xs[0].xa0.qb[124])=0.9
.ic v(xs[0].xa0.q[125])=0.3 v(xs[0].xa0.qb[125])=0.9
.ic v(xs[0].xa0.q[126])=0.3 v(xs[0].xa0.qb[126])=0.9
.ic v(xs[0].xa0.q[127])=0.3 v(xs[0].xa0.qb[127])=0.9
.ic v(xs[0].xa1.q[0])=0.3 v(xs[0].xa1.qb[0])=0.9
.ic v(xs[0].xa1.q[1])=0.3 v(xs[0].xa1.qb[1])=0.9
.ic v(xs[0].xa1.q[2])=0.3 v(xs[0].xa1.qb[2])=0.9
.ic v(xs[0].xa1.q[3])=0.3 v(xs[0].xa1.qb[3])=0.9
.ic v(xs[0].xa1.q[4])=0.3 v(xs[0].xa1.qb[4])=0.9
.ic v(xs[0].xa1.q[5])=0.3 v(xs[0].xa1.qb[5])=0.9
.ic v(xs[0].xa1.q[6])=0.3 v(xs[0].xa1.qb[6])=0.9
.ic v(xs[0].xa1.q[7])=0.3 v(xs[0].xa1.qb[7])=0.9
.ic v(xs[0].xa1.q[8])=0.3 v(xs[0].xa1.qb[8])=0.9
.ic v(xs[0].xa1.q[9])=0.3 v(xs[0].xa1.qb[9])=0.9
.ic v(xs[0].xa1.q[10])=0.3 v(xs[0].xa1.qb[10])=0.9
.ic v(xs[0].xa1.q[11])=0.3 v(xs[0].xa1.qb[11])=0.9
.ic v(xs[0].xa1.q[12])=0.3 v(xs[0].xa1.qb[12])=0.9
.ic v(xs[0].xa1.q[13])=0.3 v(xs[0].xa1.qb[13])=0.9
.ic v(xs[0].xa1.q[14])=0.3 v(xs[0].xa1.qb[14])=0.9
.ic v(xs[0].xa1.q[15])=0.3 v(xs[0].xa1.qb[15])=0.9
.ic v(xs[0].xa1.q[16])=0.3 v(xs[0].xa1.qb[16])=0.9
.ic v(xs[0].xa1.q[17])=0.3 v(xs[0].xa1.qb[17])=0.9
.ic v(xs[0].xa1.q[18])=0.3 v(xs[0].xa1.qb[18])=0.9
.ic v(xs[0].xa1.q[19])=0.3 v(xs[0].xa1.qb[19])=0.9
.ic v(xs[0].xa1.q[20])=0.3 v(xs[0].xa1.qb[20])=0.9
.ic v(xs[0].xa1.q[21])=0.3 v(xs[0].xa1.qb[21])=0.9
.ic v(xs[0].xa1.q[22])=0.3 v(xs[0].xa1.qb[22])=0.9
.ic v(xs[0].xa1.q[23])=0.3 v(xs[0].xa1.qb[23])=0.9
.ic v(xs[0].xa1.q[24])=0.3 v(xs[0].xa1.qb[24])=0.9
.ic v(xs[0].xa1.q[25])=0.3 v(xs[0].xa1.qb[25])=0.9
.ic v(xs[0].xa1.q[26])=0.3 v(xs[0].xa1.qb[26])=0.9
.ic v(xs[0].xa1.q[27])=0.3 v(xs[0].xa1.qb[27])=0.9
.ic v(xs[0].xa1.q[28])=0.3 v(xs[0].xa1.qb[28])=0.9
.ic v(xs[0].xa1.q[29])=0.3 v(xs[0].xa1.qb[29])=0.9
.ic v(xs[0].xa1.q[30])=0.3 v(xs[0].xa1.qb[30])=0.9
.ic v(xs[0].xa1.q[31])=0.3 v(xs[0].xa1.qb[31])=0.9
.ic v(xs[0].xa1.q[32])=0.3 v(xs[0].xa1.qb[32])=0.9
.ic v(xs[0].xa1.q[33])=0.3 v(xs[0].xa1.qb[33])=0.9
.ic v(xs[0].xa1.q[34])=0.3 v(xs[0].xa1.qb[34])=0.9
.ic v(xs[0].xa1.q[35])=0.3 v(xs[0].xa1.qb[35])=0.9
.ic v(xs[0].xa1.q[36])=0.3 v(xs[0].xa1.qb[36])=0.9
.ic v(xs[0].xa1.q[37])=0.3 v(xs[0].xa1.qb[37])=0.9
.ic v(xs[0].xa1.q[38])=0.3 v(xs[0].xa1.qb[38])=0.9
.ic v(xs[0].xa1.q[39])=0.3 v(xs[0].xa1.qb[39])=0.9
.ic v(xs[0].xa1.q[40])=0.3 v(xs[0].xa1.qb[40])=0.9
.ic v(xs[0].xa1.q[41])=0.3 v(xs[0].xa1.qb[41])=0.9
.ic v(xs[0].xa1.q[42])=0.3 v(xs[0].xa1.qb[42])=0.9
.ic v(xs[0].xa1.q[43])=0.3 v(xs[0].xa1.qb[43])=0.9
.ic v(xs[0].xa1.q[44])=0.3 v(xs[0].xa1.qb[44])=0.9
.ic v(xs[0].xa1.q[45])=0.3 v(xs[0].xa1.qb[45])=0.9
.ic v(xs[0].xa1.q[46])=0.3 v(xs[0].xa1.qb[46])=0.9
.ic v(xs[0].xa1.q[47])=0.3 v(xs[0].xa1.qb[47])=0.9
.ic v(xs[0].xa1.q[48])=0.3 v(xs[0].xa1.qb[48])=0.9
.ic v(xs[0].xa1.q[49])=0.3 v(xs[0].xa1.qb[49])=0.9
.ic v(xs[0].xa1.q[50])=0.3 v(xs[0].xa1.qb[50])=0.9
.ic v(xs[0].xa1.q[51])=0.3 v(xs[0].xa1.qb[51])=0.9
.ic v(xs[0].xa1.q[52])=0.3 v(xs[0].xa1.qb[52])=0.9
.ic v(xs[0].xa1.q[53])=0.3 v(xs[0].xa1.qb[53])=0.9
.ic v(xs[0].xa1.q[54])=0.3 v(xs[0].xa1.qb[54])=0.9
.ic v(xs[0].xa1.q[55])=0.3 v(xs[0].xa1.qb[55])=0.9
.ic v(xs[0].xa1.q[56])=0.3 v(xs[0].xa1.qb[56])=0.9
.ic v(xs[0].xa1.q[57])=0.3 v(xs[0].xa1.qb[57])=0.9
.ic v(xs[0].xa1.q[58])=0.3 v(xs[0].xa1.qb[58])=0.9
.ic v(xs[0].xa1.q[59])=0.3 v(xs[0].xa1.qb[59])=0.9
.ic v(xs[0].xa1.q[60])=0.3 v(xs[0].xa1.qb[60])=0.9
.ic v(xs[0].xa1.q[61])=0.3 v(xs[0].xa1.qb[61])=0.9
.ic v(xs[0].xa1.q[62])=0.3 v(xs[0].xa1.qb[62])=0.9
.ic v(xs[0].xa1.q[63])=0.3 v(xs[0].xa1.qb[63])=0.9
.ic v(xs[0].xa1.q[64])=0.3 v(xs[0].xa1.qb[64])=0.9
.ic v(xs[0].xa1.q[65])=0.3 v(xs[0].xa1.qb[65])=0.9
.ic v(xs[0].xa1.q[66])=0.3 v(xs[0].xa1.qb[66])=0.9
.ic v(xs[0].xa1.q[67])=0.3 v(xs[0].xa1.qb[67])=0.9
.ic v(xs[0].xa1.q[68])=0.3 v(xs[0].xa1.qb[68])=0.9
.ic v(xs[0].xa1.q[69])=0.3 v(xs[0].xa1.qb[69])=0.9
.ic v(xs[0].xa1.q[70])=0.3 v(xs[0].xa1.qb[70])=0.9
.ic v(xs[0].xa1.q[71])=0.3 v(xs[0].xa1.qb[71])=0.9
.ic v(xs[0].xa1.q[72])=0.3 v(xs[0].xa1.qb[72])=0.9
.ic v(xs[0].xa1.q[73])=0.3 v(xs[0].xa1.qb[73])=0.9
.ic v(xs[0].xa1.q[74])=0.3 v(xs[0].xa1.qb[74])=0.9
.ic v(xs[0].xa1.q[75])=0.3 v(xs[0].xa1.qb[75])=0.9
.ic v(xs[0].xa1.q[76])=0.3 v(xs[0].xa1.qb[76])=0.9
.ic v(xs[0].xa1.q[77])=0.3 v(xs[0].xa1.qb[77])=0.9
.ic v(xs[0].xa1.q[78])=0.3 v(xs[0].xa1.qb[78])=0.9
.ic v(xs[0].xa1.q[79])=0.3 v(xs[0].xa1.qb[79])=0.9
.ic v(xs[0].xa1.q[80])=0.3 v(xs[0].xa1.qb[80])=0.9
.ic v(xs[0].xa1.q[81])=0.3 v(xs[0].xa1.qb[81])=0.9
.ic v(xs[0].xa1.q[82])=0.3 v(xs[0].xa1.qb[82])=0.9
.ic v(xs[0].xa1.q[83])=0.3 v(xs[0].xa1.qb[83])=0.9
.ic v(xs[0].xa1.q[84])=0.3 v(xs[0].xa1.qb[84])=0.9
.ic v(xs[0].xa1.q[85])=0.3 v(xs[0].xa1.qb[85])=0.9
.ic v(xs[0].xa1.q[86])=0.3 v(xs[0].xa1.qb[86])=0.9
.ic v(xs[0].xa1.q[87])=0.3 v(xs[0].xa1.qb[87])=0.9
.ic v(xs[0].xa1.q[88])=0.3 v(xs[0].xa1.qb[88])=0.9
.ic v(xs[0].xa1.q[89])=0.3 v(xs[0].xa1.qb[89])=0.9
.ic v(xs[0].xa1.q[90])=0.3 v(xs[0].xa1.qb[90])=0.9
.ic v(xs[0].xa1.q[91])=0.3 v(xs[0].xa1.qb[91])=0.9
.ic v(xs[0].xa1.q[92])=0.3 v(xs[0].xa1.qb[92])=0.9
.ic v(xs[0].xa1.q[93])=0.3 v(xs[0].xa1.qb[93])=0.9
.ic v(xs[0].xa1.q[94])=0.3 v(xs[0].xa1.qb[94])=0.9
.ic v(xs[0].xa1.q[95])=0.3 v(xs[0].xa1.qb[95])=0.9
.ic v(xs[0].xa1.q[96])=0.3 v(xs[0].xa1.qb[96])=0.9
.ic v(xs[0].xa1.q[97])=0.3 v(xs[0].xa1.qb[97])=0.9
.ic v(xs[0].xa1.q[98])=0.3 v(xs[0].xa1.qb[98])=0.9
.ic v(xs[0].xa1.q[99])=0.3 v(xs[0].xa1.qb[99])=0.9
.ic v(xs[0].xa1.q[100])=0.3 v(xs[0].xa1.qb[100])=0.9
.ic v(xs[0].xa1.q[101])=0.3 v(xs[0].xa1.qb[101])=0.9
.ic v(xs[0].xa1.q[102])=0.3 v(xs[0].xa1.qb[102])=0.9
.ic v(xs[0].xa1.q[103])=0.3 v(xs[0].xa1.qb[103])=0.9
.ic v(xs[0].xa1.q[104])=0.3 v(xs[0].xa1.qb[104])=0.9
.ic v(xs[0].xa1.q[105])=0.3 v(xs[0].xa1.qb[105])=0.9
.ic v(xs[0].xa1.q[106])=0.3 v(xs[0].xa1.qb[106])=0.9
.ic v(xs[0].xa1.q[107])=0.3 v(xs[0].xa1.qb[107])=0.9
.ic v(xs[0].xa1.q[108])=0.3 v(xs[0].xa1.qb[108])=0.9
.ic v(xs[0].xa1.q[109])=0.3 v(xs[0].xa1.qb[109])=0.9
.ic v(xs[0].xa1.q[110])=0.3 v(xs[0].xa1.qb[110])=0.9
.ic v(xs[0].xa1.q[111])=0.3 v(xs[0].xa1.qb[111])=0.9
.ic v(xs[0].xa1.q[112])=0.3 v(xs[0].xa1.qb[112])=0.9
.ic v(xs[0].xa1.q[113])=0.3 v(xs[0].xa1.qb[113])=0.9
.ic v(xs[0].xa1.q[114])=0.3 v(xs[0].xa1.qb[114])=0.9
.ic v(xs[0].xa1.q[115])=0.3 v(xs[0].xa1.qb[115])=0.9
.ic v(xs[0].xa1.q[116])=0.3 v(xs[0].xa1.qb[116])=0.9
.ic v(xs[0].xa1.q[117])=0.3 v(xs[0].xa1.qb[117])=0.9
.ic v(xs[0].xa1.q[118])=0.3 v(xs[0].xa1.qb[118])=0.9
.ic v(xs[0].xa1.q[119])=0.3 v(xs[0].xa1.qb[119])=0.9
.ic v(xs[0].xa1.q[120])=0.3 v(xs[0].xa1.qb[120])=0.9
.ic v(xs[0].xa1.q[121])=0.3 v(xs[0].xa1.qb[121])=0.9
.ic v(xs[0].xa1.q[122])=0.3 v(xs[0].xa1.qb[122])=0.9
.ic v(xs[0].xa1.q[123])=0.3 v(xs[0].xa1.qb[123])=0.9
.ic v(xs[0].xa1.q[124])=0.3 v(xs[0].xa1.qb[124])=0.9
.ic v(xs[0].xa1.q[125])=0.3 v(xs[0].xa1.qb[125])=0.9
.ic v(xs[0].xa1.q[126])=0.3 v(xs[0].xa1.qb[126])=0.9
.ic v(xs[0].xa1.q[127])=0.3 v(xs[0].xa1.qb[127])=0.9
.ic v(dq0)=0.3 v(dqb0)=0.9
.ic v(dq1)=0.3 v(dqb1)=0.9
.ic v(dq2)=0.3 v(dqb2)=0.9
.ic v(dq3)=0.3 v(dqb3)=0.9
.ic v(dq4)=0.3 v(dqb4)=0.9
.ic v(dq5)=0.3 v(dqb5)=0.9
.ic v(dq6)=0.3 v(dqb6)=0.9
.ic v(dq7)=0.3 v(dqb7)=0.9
.ic v(dq8)=0.3 v(dqb8)=0.9
.ic v(dq9)=0.3 v(dqb9)=0.9
.ic v(dq10)=0.3 v(dqb10)=0.9
.ic v(dq11)=0.3 v(dqb11)=0.9
.ic v(dq12)=0.3 v(dqb12)=0.9
.ic v(dq13)=0.3 v(dqb13)=0.9
.ic v(dq14)=0.3 v(dqb14)=0.9
.ic v(dq15)=0.3 v(dqb15)=0.9
.ic v(dq16)=0.3 v(dqb16)=0.9
.ic v(dq17)=0.3 v(dqb17)=0.9
.ic v(dq18)=0.3 v(dqb18)=0.9
.ic v(dq19)=0.3 v(dqb19)=0.9
.ic v(dq20)=0.3 v(dqb20)=0.9
.ic v(dq21)=0.3 v(dqb21)=0.9
.ic v(dq22)=0.3 v(dqb22)=0.9
.ic v(dq23)=0.3 v(dqb23)=0.9
.ic v(dq24)=0.3 v(dqb24)=0.9
.ic v(dq25)=0.3 v(dqb25)=0.9
.ic v(dq26)=0.3 v(dqb26)=0.9
.ic v(dq27)=0.3 v(dqb27)=0.9
.ic v(dq28)=0.3 v(dqb28)=0.9
.ic v(dq29)=0.3 v(dqb29)=0.9
.ic v(dq30)=0.3 v(dqb30)=0.9
.ic v(dq31)=0.3 v(dqb31)=0.9
.ic v(dq32)=0.3 v(dqb32)=0.9
.ic v(dq33)=0.3 v(dqb33)=0.9
.ic v(dq34)=0.3 v(dqb34)=0.9
.ic v(dq35)=0.3 v(dqb35)=0.9
.ic v(dq36)=0.3 v(dqb36)=0.9
.ic v(dq37)=0.3 v(dqb37)=0.9
.ic v(dq38)=0.3 v(dqb38)=0.9
.ic v(dq39)=0.3 v(dqb39)=0.9
.ic v(dq40)=0.3 v(dqb40)=0.9
.ic v(dq41)=0.3 v(dqb41)=0.9
.ic v(dq42)=0.3 v(dqb42)=0.9
.ic v(dq43)=0.3 v(dqb43)=0.9
.ic v(dq44)=0.3 v(dqb44)=0.9
.ic v(dq45)=0.3 v(dqb45)=0.9
.ic v(dq46)=0.3 v(dqb46)=0.9
.ic v(dq47)=0.3 v(dqb47)=0.9
.ic v(dq48)=0.3 v(dqb48)=0.9
.ic v(dq49)=0.3 v(dqb49)=0.9
.ic v(dq50)=0.3 v(dqb50)=0.9
.ic v(dq51)=0.3 v(dqb51)=0.9
.ic v(dq52)=0.3 v(dqb52)=0.9
.ic v(dq53)=0.3 v(dqb53)=0.9
.ic v(dq54)=0.3 v(dqb54)=0.9
.ic v(dq55)=0.3 v(dqb55)=0.9
.ic v(dq56)=0.3 v(dqb56)=0.9
.ic v(dq57)=0.3 v(dqb57)=0.9
.ic v(dq58)=0.3 v(dqb58)=0.9
.ic v(dq59)=0.3 v(dqb59)=0.9
.ic v(dq60)=0.3 v(dqb60)=0.9
.ic v(dq61)=0.3 v(dqb61)=0.9
