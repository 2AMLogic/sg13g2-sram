* 6T bitcell write-margin bench (circuit body for `klt sim`; no .control/.end).
*
* 33 copies of design/bitcell/bitcell.spice, copy k with its BL driven to a
* constant low level L_k = 25 mV * k (k = 0..32, 0 .. 0.8 V) while BLB is held
* at VDD. The cell starts holding Q=1/QB=0 (.ic below: Q high, QB low, rail-independent).
* One wordline pulse, `pw` wide (1 ns, spec/write-pulse-width-decision.md; the
* 0.5/1/2 ns sensitivity sweep derives benches with another pw) is applied; copy
* k "flipped" if QB > Q at the end of the pulse and still at 2.5 ns. The write
* margin is the highest L_k at which the cell still flips (run_bitcell.sh
* post-processes the flip flags). Wordline amplitude = VDD. tflip_0 = time from
* 50 % WL rise to Q = QB for the BL = 0 V cell.
.param pw=1n
.include ./bitcell.spice

Vdd vdd 0 DC 1.2
* wordline pulse (0..1 normalised, scaled by VDD): 20 ps edges, `pw` plateau from 0.3 ns
Vp  p 0 PULSE(0 1 0.3n 20p 20p {pw} 10n)
Bwl wl 0 V = v(p)*v(vdd)
*      BL  BLB WL VDD VSS Q   QB
Vbl0 bl0 0 DC 0.000
Xw0 bl0 vdd wl vdd 0 q0 qb0 bitcell
Vbl1 bl1 0 DC 0.025
Xw1 bl1 vdd wl vdd 0 q1 qb1 bitcell
Vbl2 bl2 0 DC 0.050
Xw2 bl2 vdd wl vdd 0 q2 qb2 bitcell
Vbl3 bl3 0 DC 0.075
Xw3 bl3 vdd wl vdd 0 q3 qb3 bitcell
Vbl4 bl4 0 DC 0.100
Xw4 bl4 vdd wl vdd 0 q4 qb4 bitcell
Vbl5 bl5 0 DC 0.125
Xw5 bl5 vdd wl vdd 0 q5 qb5 bitcell
Vbl6 bl6 0 DC 0.150
Xw6 bl6 vdd wl vdd 0 q6 qb6 bitcell
Vbl7 bl7 0 DC 0.175
Xw7 bl7 vdd wl vdd 0 q7 qb7 bitcell
Vbl8 bl8 0 DC 0.200
Xw8 bl8 vdd wl vdd 0 q8 qb8 bitcell
Vbl9 bl9 0 DC 0.225
Xw9 bl9 vdd wl vdd 0 q9 qb9 bitcell
Vbl10 bl10 0 DC 0.250
Xw10 bl10 vdd wl vdd 0 q10 qb10 bitcell
Vbl11 bl11 0 DC 0.275
Xw11 bl11 vdd wl vdd 0 q11 qb11 bitcell
Vbl12 bl12 0 DC 0.300
Xw12 bl12 vdd wl vdd 0 q12 qb12 bitcell
Vbl13 bl13 0 DC 0.325
Xw13 bl13 vdd wl vdd 0 q13 qb13 bitcell
Vbl14 bl14 0 DC 0.350
Xw14 bl14 vdd wl vdd 0 q14 qb14 bitcell
Vbl15 bl15 0 DC 0.375
Xw15 bl15 vdd wl vdd 0 q15 qb15 bitcell
Vbl16 bl16 0 DC 0.400
Xw16 bl16 vdd wl vdd 0 q16 qb16 bitcell
Vbl17 bl17 0 DC 0.425
Xw17 bl17 vdd wl vdd 0 q17 qb17 bitcell
Vbl18 bl18 0 DC 0.450
Xw18 bl18 vdd wl vdd 0 q18 qb18 bitcell
Vbl19 bl19 0 DC 0.475
Xw19 bl19 vdd wl vdd 0 q19 qb19 bitcell
Vbl20 bl20 0 DC 0.500
Xw20 bl20 vdd wl vdd 0 q20 qb20 bitcell
Vbl21 bl21 0 DC 0.525
Xw21 bl21 vdd wl vdd 0 q21 qb21 bitcell
Vbl22 bl22 0 DC 0.550
Xw22 bl22 vdd wl vdd 0 q22 qb22 bitcell
Vbl23 bl23 0 DC 0.575
Xw23 bl23 vdd wl vdd 0 q23 qb23 bitcell
Vbl24 bl24 0 DC 0.600
Xw24 bl24 vdd wl vdd 0 q24 qb24 bitcell
Vbl25 bl25 0 DC 0.625
Xw25 bl25 vdd wl vdd 0 q25 qb25 bitcell
Vbl26 bl26 0 DC 0.650
Xw26 bl26 vdd wl vdd 0 q26 qb26 bitcell
Vbl27 bl27 0 DC 0.675
Xw27 bl27 vdd wl vdd 0 q27 qb27 bitcell
Vbl28 bl28 0 DC 0.700
Xw28 bl28 vdd wl vdd 0 q28 qb28 bitcell
Vbl29 bl29 0 DC 0.725
Xw29 bl29 vdd wl vdd 0 q29 qb29 bitcell
Vbl30 bl30 0 DC 0.750
Xw30 bl30 vdd wl vdd 0 q30 qb30 bitcell
Vbl31 bl31 0 DC 0.775
Xw31 bl31 vdd wl vdd 0 q31 qb31 bitcell
Vbl32 bl32 0 DC 0.800
Xw32 bl32 vdd wl vdd 0 q32 qb32 bitcell
.ic v(q0)=0.9 v(qb0)=0.3
.ic v(q1)=0.9 v(qb1)=0.3
.ic v(q2)=0.9 v(qb2)=0.3
.ic v(q3)=0.9 v(qb3)=0.3
.ic v(q4)=0.9 v(qb4)=0.3
.ic v(q5)=0.9 v(qb5)=0.3
.ic v(q6)=0.9 v(qb6)=0.3
.ic v(q7)=0.9 v(qb7)=0.3
.ic v(q8)=0.9 v(qb8)=0.3
.ic v(q9)=0.9 v(qb9)=0.3
.ic v(q10)=0.9 v(qb10)=0.3
.ic v(q11)=0.9 v(qb11)=0.3
.ic v(q12)=0.9 v(qb12)=0.3
.ic v(q13)=0.9 v(qb13)=0.3
.ic v(q14)=0.9 v(qb14)=0.3
.ic v(q15)=0.9 v(qb15)=0.3
.ic v(q16)=0.9 v(qb16)=0.3
.ic v(q17)=0.9 v(qb17)=0.3
.ic v(q18)=0.9 v(qb18)=0.3
.ic v(q19)=0.9 v(qb19)=0.3
.ic v(q20)=0.9 v(qb20)=0.3
.ic v(q21)=0.9 v(qb21)=0.3
.ic v(q22)=0.9 v(qb22)=0.3
.ic v(q23)=0.9 v(qb23)=0.3
.ic v(q24)=0.9 v(qb24)=0.3
.ic v(q25)=0.9 v(qb25)=0.3
.ic v(q26)=0.9 v(qb26)=0.3
.ic v(q27)=0.9 v(qb27)=0.3
.ic v(q28)=0.9 v(qb28)=0.3
.ic v(q29)=0.9 v(qb29)=0.3
.ic v(q30)=0.9 v(qb30)=0.3
.ic v(q31)=0.9 v(qb31)=0.3
.ic v(q32)=0.9 v(qb32)=0.3
