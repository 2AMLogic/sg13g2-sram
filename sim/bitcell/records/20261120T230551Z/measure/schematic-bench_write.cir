* 6T bitcell write-margin bench (circuit body for `klt sim`; no .control/.end).
*
* 33 copies of design/bitcell/bitcell.spice, copy k with its BL driven to a
* constant low level L_k = 25 mV * k (k = 0..32, 0 .. 0.8 V) while BLB is held
* at VDD. The cell starts holding Q=1/QB=0 (.ic below: Q high, QB low, rail-independent).
* One 1 ns wordline pulse (spec/write-pulse-width-decision.md) is applied; copy
* k "flipped" if QB > Q at the end of the pulse and still at 2.5 ns. The write
* margin is the highest L_k at which the cell still flips (run_bitcell.sh
* post-processes the flip flags). Wordline amplitude = VDD.
.include dut.spice

Vdd vdd 0 DC 1.2
* wordline pulse (0..1 normalised, scaled by VDD): 20 ps edges, 1 ns plateau from 0.3 ns
Vp  p 0 PULSE(0 1 0.3n 20p 20p 1n 10n)
Bwl wl 0 V = v(p)*v(vdd)
*               BL  BLB  Q  QB  VDD  VSS  WL
Vbl0 bl0 0 DC 0.000
Xw0 bl0 vdd q0 qb0 vdd 0 wl bitcell_pexrc
Vbl1 bl1 0 DC 0.025
Xw1 bl1 vdd q1 qb1 vdd 0 wl bitcell_pexrc
Vbl2 bl2 0 DC 0.050
Xw2 bl2 vdd q2 qb2 vdd 0 wl bitcell_pexrc
Vbl3 bl3 0 DC 0.075
Xw3 bl3 vdd q3 qb3 vdd 0 wl bitcell_pexrc
Vbl4 bl4 0 DC 0.100
Xw4 bl4 vdd q4 qb4 vdd 0 wl bitcell_pexrc
Vbl5 bl5 0 DC 0.125
Xw5 bl5 vdd q5 qb5 vdd 0 wl bitcell_pexrc
Vbl6 bl6 0 DC 0.150
Xw6 bl6 vdd q6 qb6 vdd 0 wl bitcell_pexrc
Vbl7 bl7 0 DC 0.175
Xw7 bl7 vdd q7 qb7 vdd 0 wl bitcell_pexrc
Vbl8 bl8 0 DC 0.200
Xw8 bl8 vdd q8 qb8 vdd 0 wl bitcell_pexrc
Vbl9 bl9 0 DC 0.225
Xw9 bl9 vdd q9 qb9 vdd 0 wl bitcell_pexrc
Vbl10 bl10 0 DC 0.250
Xw10 bl10 vdd q10 qb10 vdd 0 wl bitcell_pexrc
Vbl11 bl11 0 DC 0.275
Xw11 bl11 vdd q11 qb11 vdd 0 wl bitcell_pexrc
Vbl12 bl12 0 DC 0.300
Xw12 bl12 vdd q12 qb12 vdd 0 wl bitcell_pexrc
Vbl13 bl13 0 DC 0.325
Xw13 bl13 vdd q13 qb13 vdd 0 wl bitcell_pexrc
Vbl14 bl14 0 DC 0.350
Xw14 bl14 vdd q14 qb14 vdd 0 wl bitcell_pexrc
Vbl15 bl15 0 DC 0.375
Xw15 bl15 vdd q15 qb15 vdd 0 wl bitcell_pexrc
Vbl16 bl16 0 DC 0.400
Xw16 bl16 vdd q16 qb16 vdd 0 wl bitcell_pexrc
Vbl17 bl17 0 DC 0.425
Xw17 bl17 vdd q17 qb17 vdd 0 wl bitcell_pexrc
Vbl18 bl18 0 DC 0.450
Xw18 bl18 vdd q18 qb18 vdd 0 wl bitcell_pexrc
Vbl19 bl19 0 DC 0.475
Xw19 bl19 vdd q19 qb19 vdd 0 wl bitcell_pexrc
Vbl20 bl20 0 DC 0.500
Xw20 bl20 vdd q20 qb20 vdd 0 wl bitcell_pexrc
Vbl21 bl21 0 DC 0.525
Xw21 bl21 vdd q21 qb21 vdd 0 wl bitcell_pexrc
Vbl22 bl22 0 DC 0.550
Xw22 bl22 vdd q22 qb22 vdd 0 wl bitcell_pexrc
Vbl23 bl23 0 DC 0.575
Xw23 bl23 vdd q23 qb23 vdd 0 wl bitcell_pexrc
Vbl24 bl24 0 DC 0.600
Xw24 bl24 vdd q24 qb24 vdd 0 wl bitcell_pexrc
Vbl25 bl25 0 DC 0.625
Xw25 bl25 vdd q25 qb25 vdd 0 wl bitcell_pexrc
Vbl26 bl26 0 DC 0.650
Xw26 bl26 vdd q26 qb26 vdd 0 wl bitcell_pexrc
Vbl27 bl27 0 DC 0.675
Xw27 bl27 vdd q27 qb27 vdd 0 wl bitcell_pexrc
Vbl28 bl28 0 DC 0.700
Xw28 bl28 vdd q28 qb28 vdd 0 wl bitcell_pexrc
Vbl29 bl29 0 DC 0.725
Xw29 bl29 vdd q29 qb29 vdd 0 wl bitcell_pexrc
Vbl30 bl30 0 DC 0.750
Xw30 bl30 vdd q30 qb30 vdd 0 wl bitcell_pexrc
Vbl31 bl31 0 DC 0.775
Xw31 bl31 vdd q31 qb31 vdd 0 wl bitcell_pexrc
Vbl32 bl32 0 DC 0.800
Xw32 bl32 vdd q32 qb32 vdd 0 wl bitcell_pexrc
.ic v(q0)=0.9 v(qb0)=0.3
.ic v(q1)=0.9 v(qb1)=0.3
.ic v(q2)=0.9 v(qb2)=0.3
.ic v(q3)=0.9 v(qb3)=0.3
.ic v(q4)=0.9 v(qb4)=0.3
.ic v(q5)=0.9 v(qb5)=0.3
.ic v(q6)=0.9 v(qb6)=0.3
.ic v(q7)=0.9 v(qb7)=0.3
.ic v(q8)=0.9 v(qb8)=0.3
.ic v(q9)=0.9 v(qb9)=0.3
.ic v(q10)=0.9 v(qb10)=0.3
.ic v(q11)=0.9 v(qb11)=0.3
.ic v(q12)=0.9 v(qb12)=0.3
.ic v(q13)=0.9 v(qb13)=0.3
.ic v(q14)=0.9 v(qb14)=0.3
.ic v(q15)=0.9 v(qb15)=0.3
.ic v(q16)=0.9 v(qb16)=0.3
.ic v(q17)=0.9 v(qb17)=0.3
.ic v(q18)=0.9 v(qb18)=0.3
.ic v(q19)=0.9 v(qb19)=0.3
.ic v(q20)=0.9 v(qb20)=0.3
.ic v(q21)=0.9 v(qb21)=0.3
.ic v(q22)=0.9 v(qb22)=0.3
.ic v(q23)=0.9 v(qb23)=0.3
.ic v(q24)=0.9 v(qb24)=0.3
.ic v(q25)=0.9 v(qb25)=0.3
.ic v(q26)=0.9 v(qb26)=0.3
.ic v(q27)=0.9 v(qb27)=0.3
.ic v(q28)=0.9 v(qb28)=0.3
.ic v(q29)=0.9 v(qb29)=0.3
.ic v(q30)=0.9 v(qb30)=0.3
.ic v(q31)=0.9 v(qb31)=0.3
.ic v(q32)=0.9 v(qb32)=0.3
