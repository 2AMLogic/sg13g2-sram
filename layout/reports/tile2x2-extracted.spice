* extracted by klt extract --deck sg13g2

* cell sg13g2_sram_bitcell_tile2x2
* pin BL0
* pin BL1
* pin BLB0
* pin BLB1
* pin VDD
* pin VSS
* pin WL0
* pin WL1
.SUBCKT sg13g2_sram_bitcell_tile2x2 BL0 BL1 BLB0 BLB1 VDD VSS WL0 WL1
* device instance $1 r0 *1 0.55,1.17 nfet
M$1 \$6 WL0 BL0 VSS nfet L=0.13U W=0.3U AS=0.114P AD=0.069P PS=1.36U PD=0.76U
* device instance $2 r0 *1 1.14,1.17 nfet
M$2 VSS \$3 \$6 VSS nfet L=0.13U W=0.3U AS=0.069P AD=0.069P PS=0.76U PD=0.76U
* device instance $3 r0 *1 1.73,1.17 nfet
M$3 \$3 \$6 VSS VSS nfet L=0.13U W=0.3U AS=0.069P AD=0.069P PS=0.76U PD=0.76U
* device instance $4 r0 *1 2.32,1.17 nfet
M$4 BLB0 WL0 \$3 VSS nfet L=0.13U W=0.3U AS=0.069P AD=0.114P PS=0.76U PD=1.36U
* device instance $5 r0 *1 3.42,1.17 nfet
M$5 \$10 WL0 BLB1 VSS nfet L=0.13U W=0.3U AS=0.114P AD=0.069P PS=1.36U PD=0.76U
* device instance $6 r0 *1 4.01,1.17 nfet
M$6 VSS \$4 \$10 VSS nfet L=0.13U W=0.3U AS=0.069P AD=0.069P PS=0.76U PD=0.76U
* device instance $7 r0 *1 4.6,1.17 nfet
M$7 \$4 \$10 VSS VSS nfet L=0.13U W=0.3U AS=0.069P AD=0.069P PS=0.76U PD=0.76U
* device instance $8 r0 *1 5.19,1.17 nfet
M$8 BL1 WL0 \$4 VSS nfet L=0.13U W=0.3U AS=0.069P AD=0.114P PS=0.76U PD=1.36U
* device instance $9 r0 *1 0.55,6.04 nfet
M$9 \$12 WL1 BL0 VSS nfet L=0.13U W=0.3U AS=0.114P AD=0.069P PS=1.36U PD=0.76U
* device instance $10 r0 *1 1.14,6.04 nfet
M$10 VSS \$15 \$12 VSS nfet L=0.13U W=0.3U AS=0.069P AD=0.069P PS=0.76U PD=0.76U
* device instance $11 r0 *1 1.73,6.04 nfet
M$11 \$15 \$12 VSS VSS nfet L=0.13U W=0.3U AS=0.069P AD=0.069P PS=0.76U PD=0.76U
* device instance $12 r0 *1 2.32,6.04 nfet
M$12 BLB0 WL1 \$15 VSS nfet L=0.13U W=0.3U AS=0.069P AD=0.114P PS=0.76U PD=1.36U
* device instance $13 r0 *1 3.42,6.04 nfet
M$13 \$13 WL1 BLB1 VSS nfet L=0.13U W=0.3U AS=0.114P AD=0.069P PS=1.36U PD=0.76U
* device instance $14 r0 *1 4.01,6.04 nfet
M$14 VSS \$16 \$13 VSS nfet L=0.13U W=0.3U AS=0.069P AD=0.069P PS=0.76U PD=0.76U
* device instance $15 r0 *1 4.6,6.04 nfet
M$15 \$16 \$13 VSS VSS nfet L=0.13U W=0.3U AS=0.069P AD=0.069P PS=0.76U PD=0.76U
* device instance $16 r0 *1 5.19,6.04 nfet
M$16 BL1 WL1 \$16 VSS nfet L=0.13U W=0.3U AS=0.069P AD=0.114P PS=0.76U PD=1.36U
* device instance $17 r0 *1 1.14,2.495 pfet
M$17 VDD \$3 \$6 VDD pfet L=0.13U W=0.15U AS=0.102P AD=0.057P PS=1.36U PD=0.76U
* device instance $18 r0 *1 1.73,2.495 pfet
M$18 \$3 \$6 VDD VDD pfet L=0.13U W=0.15U AS=0.057P AD=0.102P PS=0.76U PD=1.36U
* device instance $19 r0 *1 4.01,2.495 pfet
M$19 VDD \$4 \$10 VDD pfet L=0.13U W=0.15U AS=0.102P AD=0.057P PS=1.36U PD=0.76U
* device instance $20 r0 *1 4.6,2.495 pfet
M$20 \$4 \$10 VDD VDD pfet L=0.13U W=0.15U AS=0.057P AD=0.102P PS=0.76U PD=1.36U
* device instance $21 r0 *1 1.14,4.715 pfet
M$21 VDD \$15 \$12 VDD pfet L=0.13U W=0.15U AS=0.102P AD=0.057P PS=1.36U
+ PD=0.76U
* device instance $22 r0 *1 1.73,4.715 pfet
M$22 \$15 \$12 VDD VDD pfet L=0.13U W=0.15U AS=0.057P AD=0.102P PS=0.76U
+ PD=1.36U
* device instance $23 r0 *1 4.01,4.715 pfet
M$23 VDD \$16 \$13 VDD pfet L=0.13U W=0.15U AS=0.102P AD=0.057P PS=1.36U
+ PD=0.76U
* device instance $24 r0 *1 4.6,4.715 pfet
M$24 \$16 \$13 VDD VDD pfet L=0.13U W=0.15U AS=0.057P AD=0.102P PS=0.76U
+ PD=1.36U
.ENDS sg13g2_sram_bitcell_tile2x2
